* NGSPICE file created from router_1x3.ext - technology: sky130A

* Black-box entry subcircuit for sky130_fd_sc_hd__tapvpwrvgnd_1 abstract view
.subckt sky130_fd_sc_hd__tapvpwrvgnd_1 VGND VPWR
.ends

* Black-box entry subcircuit for sky130_fd_sc_hd__a22o_1 abstract view
.subckt sky130_fd_sc_hd__a22o_1 A1 A2 B1 B2 VGND VNB VPB VPWR X
.ends

* Black-box entry subcircuit for sky130_fd_sc_hd__o311a_1 abstract view
.subckt sky130_fd_sc_hd__o311a_1 A1 A2 A3 B1 C1 VGND VNB VPB VPWR X
.ends

* Black-box entry subcircuit for sky130_fd_sc_hd__fill_1 abstract view
.subckt sky130_fd_sc_hd__fill_1 VGND VNB VPB VPWR
.ends

* Black-box entry subcircuit for sky130_fd_sc_hd__decap_3 abstract view
.subckt sky130_fd_sc_hd__decap_3 VGND VNB VPB VPWR
.ends

* Black-box entry subcircuit for sky130_fd_sc_hd__decap_4 abstract view
.subckt sky130_fd_sc_hd__decap_4 VGND VNB VPB VPWR
.ends

* Black-box entry subcircuit for sky130_ef_sc_hd__decap_12 abstract view
.subckt sky130_ef_sc_hd__decap_12 VPWR VGND VPB VNB
.ends

* Black-box entry subcircuit for sky130_fd_sc_hd__nand4_2 abstract view
.subckt sky130_fd_sc_hd__nand4_2 A B C D VGND VNB VPB VPWR Y
.ends

* Black-box entry subcircuit for sky130_fd_sc_hd__nand2_1 abstract view
.subckt sky130_fd_sc_hd__nand2_1 A B VGND VNB VPB VPWR Y
.ends

* Black-box entry subcircuit for sky130_fd_sc_hd__fill_2 abstract view
.subckt sky130_fd_sc_hd__fill_2 VGND VNB VPB VPWR
.ends

* Black-box entry subcircuit for sky130_fd_sc_hd__dfxtp_1 abstract view
.subckt sky130_fd_sc_hd__dfxtp_1 CLK D VGND VNB VPB VPWR Q
.ends

* Black-box entry subcircuit for sky130_fd_sc_hd__decap_6 abstract view
.subckt sky130_fd_sc_hd__decap_6 VGND VNB VPB VPWR
.ends

* Black-box entry subcircuit for sky130_fd_sc_hd__or2_1 abstract view
.subckt sky130_fd_sc_hd__or2_1 A B VGND VNB VPB VPWR X
.ends

* Black-box entry subcircuit for sky130_fd_sc_hd__o21ai_2 abstract view
.subckt sky130_fd_sc_hd__o21ai_2 A1 A2 B1 VGND VNB VPB VPWR Y
.ends

* Black-box entry subcircuit for sky130_fd_sc_hd__decap_8 abstract view
.subckt sky130_fd_sc_hd__decap_8 VGND VNB VPB VPWR
.ends

* Black-box entry subcircuit for sky130_fd_sc_hd__o311a_4 abstract view
.subckt sky130_fd_sc_hd__o311a_4 A1 A2 A3 B1 C1 VGND VNB VPB VPWR X
.ends

* Black-box entry subcircuit for sky130_fd_sc_hd__and4_1 abstract view
.subckt sky130_fd_sc_hd__and4_1 A B C D VGND VNB VPB VPWR X
.ends

* Black-box entry subcircuit for sky130_fd_sc_hd__a31o_1 abstract view
.subckt sky130_fd_sc_hd__a31o_1 A1 A2 A3 B1 VGND VNB VPB VPWR X
.ends

* Black-box entry subcircuit for sky130_fd_sc_hd__a32o_1 abstract view
.subckt sky130_fd_sc_hd__a32o_1 A1 A2 A3 B1 B2 VGND VNB VPB VPWR X
.ends

* Black-box entry subcircuit for sky130_fd_sc_hd__o22a_1 abstract view
.subckt sky130_fd_sc_hd__o22a_1 A1 A2 B1 B2 VGND VNB VPB VPWR X
.ends

* Black-box entry subcircuit for sky130_fd_sc_hd__o21a_1 abstract view
.subckt sky130_fd_sc_hd__o21a_1 A1 A2 B1 VGND VNB VPB VPWR X
.ends

* Black-box entry subcircuit for sky130_fd_sc_hd__dlygate4sd3_1 abstract view
.subckt sky130_fd_sc_hd__dlygate4sd3_1 A VGND VNB VPB VPWR X
.ends

* Black-box entry subcircuit for sky130_fd_sc_hd__o211a_1 abstract view
.subckt sky130_fd_sc_hd__o211a_1 A1 A2 B1 C1 VGND VNB VPB VPWR X
.ends

* Black-box entry subcircuit for sky130_fd_sc_hd__o211ai_1 abstract view
.subckt sky130_fd_sc_hd__o211ai_1 A1 A2 B1 C1 VGND VNB VPB VPWR Y
.ends

* Black-box entry subcircuit for sky130_fd_sc_hd__clkbuf_4 abstract view
.subckt sky130_fd_sc_hd__clkbuf_4 A VGND VNB VPB VPWR X
.ends

* Black-box entry subcircuit for sky130_fd_sc_hd__clkbuf_1 abstract view
.subckt sky130_fd_sc_hd__clkbuf_1 A VGND VNB VPB VPWR X
.ends

* Black-box entry subcircuit for sky130_fd_sc_hd__buf_4 abstract view
.subckt sky130_fd_sc_hd__buf_4 A VGND VNB VPB VPWR X
.ends

* Black-box entry subcircuit for sky130_fd_sc_hd__o311ai_1 abstract view
.subckt sky130_fd_sc_hd__o311ai_1 A1 A2 A3 B1 C1 VGND VNB VPB VPWR Y
.ends

* Black-box entry subcircuit for sky130_fd_sc_hd__a21oi_1 abstract view
.subckt sky130_fd_sc_hd__a21oi_1 A1 A2 B1 VGND VNB VPB VPWR Y
.ends

* Black-box entry subcircuit for sky130_fd_sc_hd__o21ai_1 abstract view
.subckt sky130_fd_sc_hd__o21ai_1 A1 A2 B1 VGND VNB VPB VPWR Y
.ends

* Black-box entry subcircuit for sky130_fd_sc_hd__nand2_2 abstract view
.subckt sky130_fd_sc_hd__nand2_2 A B VGND VNB VPB VPWR Y
.ends

* Black-box entry subcircuit for sky130_fd_sc_hd__a21bo_1 abstract view
.subckt sky130_fd_sc_hd__a21bo_1 A1 A2 B1_N VGND VNB VPB VPWR X
.ends

* Black-box entry subcircuit for sky130_fd_sc_hd__nor2_2 abstract view
.subckt sky130_fd_sc_hd__nor2_2 A B VGND VNB VPB VPWR Y
.ends

* Black-box entry subcircuit for sky130_fd_sc_hd__nor2b_2 abstract view
.subckt sky130_fd_sc_hd__nor2b_2 A B_N VGND VNB VPB VPWR Y
.ends

* Black-box entry subcircuit for sky130_fd_sc_hd__clkbuf_16 abstract view
.subckt sky130_fd_sc_hd__clkbuf_16 A VGND VNB VPB VPWR X
.ends

* Black-box entry subcircuit for sky130_fd_sc_hd__o21bai_1 abstract view
.subckt sky130_fd_sc_hd__o21bai_1 A1 A2 B1_N VGND VNB VPB VPWR Y
.ends

* Black-box entry subcircuit for sky130_fd_sc_hd__a21o_1 abstract view
.subckt sky130_fd_sc_hd__a21o_1 A1 A2 B1 VGND VNB VPB VPWR X
.ends

* Black-box entry subcircuit for sky130_fd_sc_hd__nand4b_1 abstract view
.subckt sky130_fd_sc_hd__nand4b_1 A_N B C D VGND VNB VPB VPWR Y
.ends

* Black-box entry subcircuit for sky130_fd_sc_hd__mux4_1 abstract view
.subckt sky130_fd_sc_hd__mux4_1 A0 A1 A2 A3 S0 S1 VGND VNB VPB VPWR X
.ends

* Black-box entry subcircuit for sky130_fd_sc_hd__and4b_1 abstract view
.subckt sky130_fd_sc_hd__and4b_1 A_N B C D VGND VNB VPB VPWR X
.ends

* Black-box entry subcircuit for sky130_fd_sc_hd__diode_2 abstract view
.subckt sky130_fd_sc_hd__diode_2 DIODE VGND VNB VPB VPWR
.ends

* Black-box entry subcircuit for sky130_fd_sc_hd__nand4_1 abstract view
.subckt sky130_fd_sc_hd__nand4_1 A B C D VGND VNB VPB VPWR Y
.ends

* Black-box entry subcircuit for sky130_fd_sc_hd__dfxtp_2 abstract view
.subckt sky130_fd_sc_hd__dfxtp_2 CLK D VGND VNB VPB VPWR Q
.ends

* Black-box entry subcircuit for sky130_fd_sc_hd__buf_2 abstract view
.subckt sky130_fd_sc_hd__buf_2 A VGND VNB VPB VPWR X
.ends

* Black-box entry subcircuit for sky130_fd_sc_hd__o41a_1 abstract view
.subckt sky130_fd_sc_hd__o41a_1 A1 A2 A3 A4 B1 VGND VNB VPB VPWR X
.ends

* Black-box entry subcircuit for sky130_fd_sc_hd__and3_1 abstract view
.subckt sky130_fd_sc_hd__and3_1 A B C VGND VNB VPB VPWR X
.ends

* Black-box entry subcircuit for sky130_fd_sc_hd__inv_2 abstract view
.subckt sky130_fd_sc_hd__inv_2 A VGND VNB VPB VPWR Y
.ends

* Black-box entry subcircuit for sky130_fd_sc_hd__o22ai_1 abstract view
.subckt sky130_fd_sc_hd__o22ai_1 A1 A2 B1 B2 VGND VNB VPB VPWR Y
.ends

* Black-box entry subcircuit for sky130_fd_sc_hd__o31a_4 abstract view
.subckt sky130_fd_sc_hd__o31a_4 A1 A2 A3 B1 VGND VNB VPB VPWR X
.ends

* Black-box entry subcircuit for sky130_fd_sc_hd__mux2_1 abstract view
.subckt sky130_fd_sc_hd__mux2_1 A0 A1 S VGND VNB VPB VPWR X
.ends

* Black-box entry subcircuit for sky130_fd_sc_hd__and3b_1 abstract view
.subckt sky130_fd_sc_hd__and3b_1 A_N B C VGND VNB VPB VPWR X
.ends

* Black-box entry subcircuit for sky130_fd_sc_hd__o21ba_1 abstract view
.subckt sky130_fd_sc_hd__o21ba_1 A1 A2 B1_N VGND VNB VPB VPWR X
.ends

* Black-box entry subcircuit for sky130_fd_sc_hd__and2b_1 abstract view
.subckt sky130_fd_sc_hd__and2b_1 A_N B VGND VNB VPB VPWR X
.ends

* Black-box entry subcircuit for sky130_fd_sc_hd__nor3_1 abstract view
.subckt sky130_fd_sc_hd__nor3_1 A B C VGND VNB VPB VPWR Y
.ends

* Black-box entry subcircuit for sky130_fd_sc_hd__and2_2 abstract view
.subckt sky130_fd_sc_hd__and2_2 A B VGND VNB VPB VPWR X
.ends

* Black-box entry subcircuit for sky130_fd_sc_hd__a31oi_4 abstract view
.subckt sky130_fd_sc_hd__a31oi_4 A1 A2 A3 B1 VGND VNB VPB VPWR Y
.ends

* Black-box entry subcircuit for sky130_fd_sc_hd__nand3_1 abstract view
.subckt sky130_fd_sc_hd__nand3_1 A B C VGND VNB VPB VPWR Y
.ends

* Black-box entry subcircuit for sky130_fd_sc_hd__a221oi_1 abstract view
.subckt sky130_fd_sc_hd__a221oi_1 A1 A2 B1 B2 C1 VGND VNB VPB VPWR Y
.ends

* Black-box entry subcircuit for sky130_fd_sc_hd__nor2_4 abstract view
.subckt sky130_fd_sc_hd__nor2_4 A B VGND VNB VPB VPWR Y
.ends

* Black-box entry subcircuit for sky130_fd_sc_hd__o211ai_4 abstract view
.subckt sky130_fd_sc_hd__o211ai_4 A1 A2 B1 C1 VGND VNB VPB VPWR Y
.ends

* Black-box entry subcircuit for sky130_fd_sc_hd__a21oi_4 abstract view
.subckt sky130_fd_sc_hd__a21oi_4 A1 A2 B1 VGND VNB VPB VPWR Y
.ends

* Black-box entry subcircuit for sky130_fd_sc_hd__a31oi_1 abstract view
.subckt sky130_fd_sc_hd__a31oi_1 A1 A2 A3 B1 VGND VNB VPB VPWR Y
.ends

* Black-box entry subcircuit for sky130_fd_sc_hd__a21oi_2 abstract view
.subckt sky130_fd_sc_hd__a21oi_2 A1 A2 B1 VGND VNB VPB VPWR Y
.ends

* Black-box entry subcircuit for sky130_fd_sc_hd__nand4_4 abstract view
.subckt sky130_fd_sc_hd__nand4_4 A B C D VGND VNB VPB VPWR Y
.ends

* Black-box entry subcircuit for sky130_fd_sc_hd__and3_2 abstract view
.subckt sky130_fd_sc_hd__and3_2 A B C VGND VNB VPB VPWR X
.ends

* Black-box entry subcircuit for sky130_fd_sc_hd__nor2_1 abstract view
.subckt sky130_fd_sc_hd__nor2_1 A B VGND VNB VPB VPWR Y
.ends

* Black-box entry subcircuit for sky130_fd_sc_hd__o21ai_4 abstract view
.subckt sky130_fd_sc_hd__o21ai_4 A1 A2 B1 VGND VNB VPB VPWR Y
.ends

* Black-box entry subcircuit for sky130_fd_sc_hd__a41o_1 abstract view
.subckt sky130_fd_sc_hd__a41o_1 A1 A2 A3 A4 B1 VGND VNB VPB VPWR X
.ends

* Black-box entry subcircuit for sky130_fd_sc_hd__a21boi_1 abstract view
.subckt sky130_fd_sc_hd__a21boi_1 A1 A2 B1_N VGND VNB VPB VPWR Y
.ends

* Black-box entry subcircuit for sky130_fd_sc_hd__o31a_1 abstract view
.subckt sky130_fd_sc_hd__o31a_1 A1 A2 A3 B1 VGND VNB VPB VPWR X
.ends

* Black-box entry subcircuit for sky130_fd_sc_hd__o22ai_2 abstract view
.subckt sky130_fd_sc_hd__o22ai_2 A1 A2 B1 B2 VGND VNB VPB VPWR Y
.ends

* Black-box entry subcircuit for sky130_fd_sc_hd__or2b_1 abstract view
.subckt sky130_fd_sc_hd__or2b_1 A B_N VGND VNB VPB VPWR X
.ends

* Black-box entry subcircuit for sky130_fd_sc_hd__or3b_1 abstract view
.subckt sky130_fd_sc_hd__or3b_1 A B C_N VGND VNB VPB VPWR X
.ends

* Black-box entry subcircuit for sky130_fd_sc_hd__clkbuf_8 abstract view
.subckt sky130_fd_sc_hd__clkbuf_8 A VGND VNB VPB VPWR X
.ends

* Black-box entry subcircuit for sky130_fd_sc_hd__a32oi_4 abstract view
.subckt sky130_fd_sc_hd__a32oi_4 A1 A2 A3 B1 B2 VGND VNB VPB VPWR Y
.ends

* Black-box entry subcircuit for sky130_fd_sc_hd__o2bb2a_1 abstract view
.subckt sky130_fd_sc_hd__o2bb2a_1 A1_N A2_N B1 B2 VGND VNB VPB VPWR X
.ends

* Black-box entry subcircuit for sky130_fd_sc_hd__nor4_1 abstract view
.subckt sky130_fd_sc_hd__nor4_1 A B C D VGND VNB VPB VPWR Y
.ends

* Black-box entry subcircuit for sky130_fd_sc_hd__clkbuf_2 abstract view
.subckt sky130_fd_sc_hd__clkbuf_2 A VGND VNB VPB VPWR X
.ends

* Black-box entry subcircuit for sky130_fd_sc_hd__or3_2 abstract view
.subckt sky130_fd_sc_hd__or3_2 A B C VGND VNB VPB VPWR X
.ends

* Black-box entry subcircuit for sky130_fd_sc_hd__and2_1 abstract view
.subckt sky130_fd_sc_hd__and2_1 A B VGND VNB VPB VPWR X
.ends

* Black-box entry subcircuit for sky130_fd_sc_hd__nand3b_4 abstract view
.subckt sky130_fd_sc_hd__nand3b_4 A_N B C VGND VNB VPB VPWR Y
.ends

* Black-box entry subcircuit for sky130_fd_sc_hd__or3_1 abstract view
.subckt sky130_fd_sc_hd__or3_1 A B C VGND VNB VPB VPWR X
.ends

* Black-box entry subcircuit for sky130_fd_sc_hd__and4b_2 abstract view
.subckt sky130_fd_sc_hd__and4b_2 A_N B C D VGND VNB VPB VPWR X
.ends

* Black-box entry subcircuit for sky130_fd_sc_hd__mux4_2 abstract view
.subckt sky130_fd_sc_hd__mux4_2 A0 A1 A2 A3 S0 S1 VGND VNB VPB VPWR X
.ends

* Black-box entry subcircuit for sky130_fd_sc_hd__o22a_4 abstract view
.subckt sky130_fd_sc_hd__o22a_4 A1 A2 B1 B2 VGND VNB VPB VPWR X
.ends

* Black-box entry subcircuit for sky130_fd_sc_hd__nand2_4 abstract view
.subckt sky130_fd_sc_hd__nand2_4 A B VGND VNB VPB VPWR Y
.ends

* Black-box entry subcircuit for sky130_fd_sc_hd__a211o_1 abstract view
.subckt sky130_fd_sc_hd__a211o_1 A1 A2 B1 C1 VGND VNB VPB VPWR X
.ends

* Black-box entry subcircuit for sky130_fd_sc_hd__nand3b_1 abstract view
.subckt sky130_fd_sc_hd__nand3b_1 A_N B C VGND VNB VPB VPWR Y
.ends

* Black-box entry subcircuit for sky130_fd_sc_hd__a41oi_4 abstract view
.subckt sky130_fd_sc_hd__a41oi_4 A1 A2 A3 A4 B1 VGND VNB VPB VPWR Y
.ends

* Black-box entry subcircuit for sky130_fd_sc_hd__or4_4 abstract view
.subckt sky130_fd_sc_hd__or4_4 A B C D VGND VNB VPB VPWR X
.ends

* Black-box entry subcircuit for sky130_fd_sc_hd__buf_6 abstract view
.subckt sky130_fd_sc_hd__buf_6 A VGND VNB VPB VPWR X
.ends

* Black-box entry subcircuit for sky130_fd_sc_hd__a221oi_2 abstract view
.subckt sky130_fd_sc_hd__a221oi_2 A1 A2 B1 B2 C1 VGND VNB VPB VPWR Y
.ends

* Black-box entry subcircuit for sky130_fd_sc_hd__dfxtp_4 abstract view
.subckt sky130_fd_sc_hd__dfxtp_4 CLK D VGND VNB VPB VPWR Q
.ends

* Black-box entry subcircuit for sky130_fd_sc_hd__o2bb2a_2 abstract view
.subckt sky130_fd_sc_hd__o2bb2a_2 A1_N A2_N B1 B2 VGND VNB VPB VPWR X
.ends

* Black-box entry subcircuit for sky130_fd_sc_hd__o31ai_4 abstract view
.subckt sky130_fd_sc_hd__o31ai_4 A1 A2 A3 B1 VGND VNB VPB VPWR Y
.ends

* Black-box entry subcircuit for sky130_fd_sc_hd__o221a_2 abstract view
.subckt sky130_fd_sc_hd__o221a_2 A1 A2 B1 B2 C1 VGND VNB VPB VPWR X
.ends

* Black-box entry subcircuit for sky130_fd_sc_hd__a211oi_1 abstract view
.subckt sky130_fd_sc_hd__a211oi_1 A1 A2 B1 C1 VGND VNB VPB VPWR Y
.ends

* Black-box entry subcircuit for sky130_fd_sc_hd__o221a_1 abstract view
.subckt sky130_fd_sc_hd__o221a_1 A1 A2 B1 B2 C1 VGND VNB VPB VPWR X
.ends

* Black-box entry subcircuit for sky130_fd_sc_hd__a22oi_2 abstract view
.subckt sky130_fd_sc_hd__a22oi_2 A1 A2 B1 B2 VGND VNB VPB VPWR Y
.ends

* Black-box entry subcircuit for sky130_fd_sc_hd__xnor2_1 abstract view
.subckt sky130_fd_sc_hd__xnor2_1 A B VGND VNB VPB VPWR Y
.ends

* Black-box entry subcircuit for sky130_fd_sc_hd__nand4b_2 abstract view
.subckt sky130_fd_sc_hd__nand4b_2 A_N B C D VGND VNB VPB VPWR Y
.ends

* Black-box entry subcircuit for sky130_fd_sc_hd__nand4b_4 abstract view
.subckt sky130_fd_sc_hd__nand4b_4 A_N B C D VGND VNB VPB VPWR Y
.ends

* Black-box entry subcircuit for sky130_fd_sc_hd__a22oi_4 abstract view
.subckt sky130_fd_sc_hd__a22oi_4 A1 A2 B1 B2 VGND VNB VPB VPWR Y
.ends

* Black-box entry subcircuit for sky130_fd_sc_hd__o31ai_1 abstract view
.subckt sky130_fd_sc_hd__o31ai_1 A1 A2 A3 B1 VGND VNB VPB VPWR Y
.ends

* Black-box entry subcircuit for sky130_fd_sc_hd__o311a_2 abstract view
.subckt sky130_fd_sc_hd__o311a_2 A1 A2 A3 B1 C1 VGND VNB VPB VPWR X
.ends

* Black-box entry subcircuit for sky130_fd_sc_hd__buf_1 abstract view
.subckt sky130_fd_sc_hd__buf_1 A VGND VNB VPB VPWR X
.ends

* Black-box entry subcircuit for sky130_fd_sc_hd__o211a_2 abstract view
.subckt sky130_fd_sc_hd__o211a_2 A1 A2 B1 C1 VGND VNB VPB VPWR X
.ends

* Black-box entry subcircuit for sky130_fd_sc_hd__and4bb_1 abstract view
.subckt sky130_fd_sc_hd__and4bb_1 A_N B_N C D VGND VNB VPB VPWR X
.ends

* Black-box entry subcircuit for sky130_fd_sc_hd__o2bb2ai_1 abstract view
.subckt sky130_fd_sc_hd__o2bb2ai_1 A1_N A2_N B1 B2 VGND VNB VPB VPWR Y
.ends

* Black-box entry subcircuit for sky130_fd_sc_hd__clkinv_4 abstract view
.subckt sky130_fd_sc_hd__clkinv_4 A VGND VNB VPB VPWR Y
.ends

* Black-box entry subcircuit for sky130_fd_sc_hd__or4b_1 abstract view
.subckt sky130_fd_sc_hd__or4b_1 A B C D_N VGND VNB VPB VPWR X
.ends

* Black-box entry subcircuit for sky130_fd_sc_hd__o41a_2 abstract view
.subckt sky130_fd_sc_hd__o41a_2 A1 A2 A3 A4 B1 VGND VNB VPB VPWR X
.ends

* Black-box entry subcircuit for sky130_fd_sc_hd__buf_8 abstract view
.subckt sky130_fd_sc_hd__buf_8 A VGND VNB VPB VPWR X
.ends

* Black-box entry subcircuit for sky130_fd_sc_hd__a41o_2 abstract view
.subckt sky130_fd_sc_hd__a41o_2 A1 A2 A3 A4 B1 VGND VNB VPB VPWR X
.ends

* Black-box entry subcircuit for sky130_fd_sc_hd__nand2b_4 abstract view
.subckt sky130_fd_sc_hd__nand2b_4 A_N B VGND VNB VPB VPWR Y
.ends

* Black-box entry subcircuit for sky130_fd_sc_hd__a22oi_1 abstract view
.subckt sky130_fd_sc_hd__a22oi_1 A1 A2 B1 B2 VGND VNB VPB VPWR Y
.ends

* Black-box entry subcircuit for sky130_fd_sc_hd__and4_2 abstract view
.subckt sky130_fd_sc_hd__and4_2 A B C D VGND VNB VPB VPWR X
.ends

* Black-box entry subcircuit for sky130_fd_sc_hd__o221ai_2 abstract view
.subckt sky130_fd_sc_hd__o221ai_2 A1 A2 B1 B2 C1 VGND VNB VPB VPWR Y
.ends

* Black-box entry subcircuit for sky130_fd_sc_hd__or4_1 abstract view
.subckt sky130_fd_sc_hd__or4_1 A B C D VGND VNB VPB VPWR X
.ends

* Black-box entry subcircuit for sky130_fd_sc_hd__or4bb_1 abstract view
.subckt sky130_fd_sc_hd__or4bb_1 A B C_N D_N VGND VNB VPB VPWR X
.ends

* Black-box entry subcircuit for sky130_fd_sc_hd__nand2b_2 abstract view
.subckt sky130_fd_sc_hd__nand2b_2 A_N B VGND VNB VPB VPWR Y
.ends

* Black-box entry subcircuit for sky130_fd_sc_hd__xor2_4 abstract view
.subckt sky130_fd_sc_hd__xor2_4 A B VGND VNB VPB VPWR X
.ends

* Black-box entry subcircuit for sky130_fd_sc_hd__o41a_4 abstract view
.subckt sky130_fd_sc_hd__o41a_4 A1 A2 A3 A4 B1 VGND VNB VPB VPWR X
.ends

* Black-box entry subcircuit for sky130_fd_sc_hd__o2111a_1 abstract view
.subckt sky130_fd_sc_hd__o2111a_1 A1 A2 B1 C1 D1 VGND VNB VPB VPWR X
.ends

* Black-box entry subcircuit for sky130_fd_sc_hd__xnor2_4 abstract view
.subckt sky130_fd_sc_hd__xnor2_4 A B VGND VNB VPB VPWR Y
.ends

* Black-box entry subcircuit for sky130_fd_sc_hd__o211ai_2 abstract view
.subckt sky130_fd_sc_hd__o211ai_2 A1 A2 B1 C1 VGND VNB VPB VPWR Y
.ends

* Black-box entry subcircuit for sky130_fd_sc_hd__a32oi_2 abstract view
.subckt sky130_fd_sc_hd__a32oi_2 A1 A2 A3 B1 B2 VGND VNB VPB VPWR Y
.ends

* Black-box entry subcircuit for sky130_fd_sc_hd__a311oi_4 abstract view
.subckt sky130_fd_sc_hd__a311oi_4 A1 A2 A3 B1 C1 VGND VNB VPB VPWR Y
.ends

* Black-box entry subcircuit for sky130_fd_sc_hd__o22a_2 abstract view
.subckt sky130_fd_sc_hd__o22a_2 A1 A2 B1 B2 VGND VNB VPB VPWR X
.ends

* Black-box entry subcircuit for sky130_fd_sc_hd__o221ai_4 abstract view
.subckt sky130_fd_sc_hd__o221ai_4 A1 A2 B1 B2 C1 VGND VNB VPB VPWR Y
.ends

* Black-box entry subcircuit for sky130_fd_sc_hd__nor3b_1 abstract view
.subckt sky130_fd_sc_hd__nor3b_1 A B C_N VGND VNB VPB VPWR Y
.ends

* Black-box entry subcircuit for sky130_fd_sc_hd__nand3_2 abstract view
.subckt sky130_fd_sc_hd__nand3_2 A B C VGND VNB VPB VPWR Y
.ends

* Black-box entry subcircuit for sky130_fd_sc_hd__and4bb_4 abstract view
.subckt sky130_fd_sc_hd__and4bb_4 A_N B_N C D VGND VNB VPB VPWR X
.ends

* Black-box entry subcircuit for sky130_fd_sc_hd__a2bb2o_1 abstract view
.subckt sky130_fd_sc_hd__a2bb2o_1 A1_N A2_N B1 B2 VGND VNB VPB VPWR X
.ends

* Black-box entry subcircuit for sky130_fd_sc_hd__o31a_2 abstract view
.subckt sky130_fd_sc_hd__o31a_2 A1 A2 A3 B1 VGND VNB VPB VPWR X
.ends

* Black-box entry subcircuit for sky130_fd_sc_hd__or2b_2 abstract view
.subckt sky130_fd_sc_hd__or2b_2 A B_N VGND VNB VPB VPWR X
.ends

* Black-box entry subcircuit for sky130_fd_sc_hd__or4_2 abstract view
.subckt sky130_fd_sc_hd__or4_2 A B C D VGND VNB VPB VPWR X
.ends

* Black-box entry subcircuit for sky130_fd_sc_hd__nand3_4 abstract view
.subckt sky130_fd_sc_hd__nand3_4 A B C VGND VNB VPB VPWR Y
.ends

* Black-box entry subcircuit for sky130_fd_sc_hd__a21o_2 abstract view
.subckt sky130_fd_sc_hd__a21o_2 A1 A2 B1 VGND VNB VPB VPWR X
.ends

.subckt router_1x3 VGND VPWR busy clock data_in[0] data_in[1] data_in[2] data_in[3]
+ data_in[4] data_in[5] data_in[6] data_in[7] data_out_0[0] data_out_0[1] data_out_0[2]
+ data_out_0[3] data_out_0[4] data_out_0[5] data_out_0[6] data_out_0[7] data_out_1[0]
+ data_out_1[1] data_out_1[2] data_out_1[3] data_out_1[4] data_out_1[5] data_out_1[6]
+ data_out_1[7] data_out_2[0] data_out_2[1] data_out_2[2] data_out_2[3] data_out_2[4]
+ data_out_2[5] data_out_2[6] data_out_2[7] error pkt_valid read_enb_0 read_enb_1
+ read_enb_2 resetn valid_out_0 valid_out_1 valid_out_2
XTAP_188 VGND VPWR sky130_fd_sc_hd__tapvpwrvgnd_1
XTAP_199 VGND VPWR sky130_fd_sc_hd__tapvpwrvgnd_1
X_3155_ _0740_ _1152_ _1153_ net345 VGND VGND VPWR VPWR _0501_ sky130_fd_sc_hd__a22o_1
X_3086_ _1759_ _1419_ _0835_ _0782_ fifo3.mem\[2\]\[3\] VGND VGND VPWR VPWR _1764_
+ sky130_fd_sc_hd__o311a_1
XFILLER_0_89_461 VGND VGND VPWR VPWR sky130_fd_sc_hd__fill_1
XFILLER_0_76_166 VGND VGND VPWR VPWR sky130_fd_sc_hd__decap_3
XFILLER_0_9_433 VGND VGND VPWR VPWR sky130_fd_sc_hd__decap_4
XFILLER_0_43_81 VPWR VGND VPWR VGND sky130_ef_sc_hd__decap_12
XFILLER_0_91_125 VPWR VGND VPWR VGND sky130_ef_sc_hd__decap_12
X_3988_ _0833_ _0776_ _0789_ _0825_ VGND VGND VPWR VPWR _0928_ sky130_fd_sc_hd__nand4_2
X_2939_ _1544_ _1642_ VGND VGND VPWR VPWR _1643_ sky130_fd_sc_hd__nand2_1
XFILLER_0_17_277 VGND VGND VPWR VPWR sky130_fd_sc_hd__decap_3
XFILLER_0_32_203 VGND VGND VPWR VPWR sky130_fd_sc_hd__fill_2
X_4609_ clknet_leaf_20_clock _0415_ VGND VGND VPWR VPWR fifo1.mem\[4\]\[2\] sky130_fd_sc_hd__dfxtp_1
XFILLER_0_7_81 VGND VGND VPWR VPWR sky130_fd_sc_hd__decap_6
XFILLER_0_70_309 VGND VGND VPWR VPWR sky130_fd_sc_hd__fill_1
XFILLER_0_63_350 VPWR VGND VPWR VGND sky130_ef_sc_hd__decap_12
XFILLER_0_58_122 VGND VGND VPWR VPWR sky130_fd_sc_hd__decap_4
X_3911_ _0656_ fsm1.addr\[1\] VGND VGND VPWR VPWR _0877_ sky130_fd_sc_hd__or2_1
X_3842_ _0631_ _0632_ _0645_ VGND VGND VPWR VPWR _0827_ sky130_fd_sc_hd__o21ai_2
XFILLER_0_73_169 VGND VGND VPWR VPWR sky130_fd_sc_hd__fill_1
XFILLER_0_73_158 VGND VGND VPWR VPWR sky130_fd_sc_hd__decap_8
XFILLER_0_73_136 VGND VGND VPWR VPWR sky130_fd_sc_hd__decap_4
X_3773_ _0633_ _0773_ _0774_ _0775_ _0634_ VGND VGND VPWR VPWR _0776_ sky130_fd_sc_hd__o311a_4
XFILLER_0_54_361 VGND VGND VPWR VPWR sky130_fd_sc_hd__decap_3
XFILLER_0_89_55 VGND VGND VPWR VPWR sky130_fd_sc_hd__fill_1
XFILLER_0_14_225 VGND VGND VPWR VPWR sky130_fd_sc_hd__decap_8
X_2724_ _1119_ _1111_ _1094_ _1123_ VGND VGND VPWR VPWR _1484_ sky130_fd_sc_hd__and4_1
X_2655_ _0797_ _0856_ _1446_ _1460_ VGND VGND VPWR VPWR _0340_ sky130_fd_sc_hd__a31o_1
XFILLER_0_1_141 VGND VGND VPWR VPWR sky130_fd_sc_hd__decap_6
X_4325_ clknet_leaf_27_clock _0139_ VGND VGND VPWR VPWR fifo2.mem\[0\]\[7\] sky130_fd_sc_hd__dfxtp_1
XFILLER_0_1_163 VGND VGND VPWR VPWR sky130_fd_sc_hd__decap_4
X_2586_ _0732_ _0869_ _1433_ _1434_ net250 VGND VGND VPWR VPWR _0297_ sky130_fd_sc_hd__a32o_1
X_4256_ clknet_leaf_2_clock _0070_ VGND VGND VPWR VPWR fifo3.mem\[1\]\[8\] sky130_fd_sc_hd__dfxtp_1
X_3207_ _1829_ _1831_ _1833_ _1836_ VGND VGND VPWR VPWR _1837_ sky130_fd_sc_hd__o22a_1
X_4187_ regis.packet_parity\[3\] _0682_ VGND VGND VPWR VPWR _1064_ sky130_fd_sc_hd__or2_1
X_3138_ _0934_ _1789_ _1795_ VGND VGND VPWR VPWR _0488_ sky130_fd_sc_hd__o21a_1
X_3069_ _0731_ _1754_ _1756_ _1757_ net132 VGND VGND VPWR VPWR _0457_ sky130_fd_sc_hd__a32o_1
XFILLER_0_49_111 VGND VGND VPWR VPWR sky130_fd_sc_hd__fill_1
Xhold170 fifo1.mem\[2\]\[4\] VGND VGND VPWR VPWR net218 sky130_fd_sc_hd__dlygate4sd3_1
Xhold181 fifo1.mem\[6\]\[1\] VGND VGND VPWR VPWR net229 sky130_fd_sc_hd__dlygate4sd3_1
Xhold192 fifo1.mem\[11\]\[1\] VGND VGND VPWR VPWR net240 sky130_fd_sc_hd__dlygate4sd3_1
XFILLER_0_28_306 VGND VGND VPWR VPWR sky130_fd_sc_hd__fill_2
XFILLER_0_50_38 VGND VGND VPWR VPWR sky130_fd_sc_hd__decap_3
XFILLER_0_55_169 VGND VGND VPWR VPWR sky130_fd_sc_hd__fill_1
XFILLER_0_70_117 VGND VGND VPWR VPWR sky130_fd_sc_hd__fill_2
XFILLER_0_3_417 VPWR VGND VPWR VGND sky130_ef_sc_hd__decap_12
XFILLER_0_24_523 VGND VGND VPWR VPWR sky130_fd_sc_hd__decap_8
XFILLER_0_51_320 VGND VGND VPWR VPWR sky130_fd_sc_hd__fill_1
XFILLER_0_70_139 VGND VGND VPWR VPWR sky130_fd_sc_hd__fill_1
XFILLER_0_51_353 VGND VGND VPWR VPWR sky130_fd_sc_hd__decap_8
X_2440_ _1227_ _1256_ _1282_ _1324_ VGND VGND VPWR VPWR _1325_ sky130_fd_sc_hd__nand4_2
XFILLER_0_51_386 VGND VGND VPWR VPWR sky130_fd_sc_hd__decap_6
X_2371_ _1227_ _1256_ _1257_ _1195_ VGND VGND VPWR VPWR _1258_ sky130_fd_sc_hd__o211a_1
X_4110_ net5 _0986_ _0989_ _1010_ VGND VGND VPWR VPWR _1011_ sky130_fd_sc_hd__o211ai_1
XFILLER_0_75_57 VGND VGND VPWR VPWR sky130_fd_sc_hd__decap_8
X_4041_ _0719_ VGND VGND VPWR VPWR _0963_ sky130_fd_sc_hd__clkbuf_4
XFILLER_0_59_431 VGND VGND VPWR VPWR sky130_fd_sc_hd__decap_3
XFILLER_0_59_442 VGND VGND VPWR VPWR sky130_fd_sc_hd__decap_6
XFILLER_0_74_412 VGND VGND VPWR VPWR sky130_fd_sc_hd__decap_8
XFILLER_0_74_489 VGND VGND VPWR VPWR sky130_fd_sc_hd__fill_1
X_3825_ _0814_ VGND VGND VPWR VPWR _0057_ sky130_fd_sc_hd__clkbuf_1
XFILLER_0_46_169 VGND VGND VPWR VPWR sky130_fd_sc_hd__fill_2
X_3756_ _0739_ VGND VGND VPWR VPWR _0763_ sky130_fd_sc_hd__buf_4
X_2707_ net333 _1478_ _1480_ _0932_ VGND VGND VPWR VPWR _0372_ sky130_fd_sc_hd__a22o_1
X_3687_ _0709_ VGND VGND VPWR VPWR _0024_ sky130_fd_sc_hd__clkbuf_1
XFILLER_0_2_450 VPWR VGND VPWR VGND sky130_ef_sc_hd__decap_12
XFILLER_0_71_3 VGND VGND VPWR VPWR sky130_fd_sc_hd__fill_1
X_2638_ _1447_ _1448_ _1450_ _1451_ fifo2.mem\[7\]\[0\] VGND VGND VPWR VPWR _1452_
+ sky130_fd_sc_hd__o311a_1
X_2569_ _0743_ _1425_ _1429_ _1430_ net50 VGND VGND VPWR VPWR _0284_ sky130_fd_sc_hd__a32o_1
X_4308_ clknet_leaf_0_clock _0122_ VGND VGND VPWR VPWR fifo3.mem\[6\]\[8\] sky130_fd_sc_hd__dfxtp_1
X_4239_ clknet_leaf_56_clock _0053_ VGND VGND VPWR VPWR fifo3.mem\[8\]\[0\] sky130_fd_sc_hd__dfxtp_1
XFILLER_0_77_261 VGND VGND VPWR VPWR sky130_fd_sc_hd__fill_2
XFILLER_0_65_445 VGND VGND VPWR VPWR sky130_fd_sc_hd__decap_3
XFILLER_0_80_459 VPWR VGND VPWR VGND sky130_ef_sc_hd__decap_12
XFILLER_0_33_353 VGND VGND VPWR VPWR sky130_fd_sc_hd__fill_1
XFILLER_0_21_526 VPWR VGND VPWR VGND sky130_ef_sc_hd__decap_12
XFILLER_0_60_194 VGND VGND VPWR VPWR sky130_fd_sc_hd__fill_2
XFILLER_0_45_27 VGND VGND VPWR VPWR sky130_fd_sc_hd__decap_3
XFILLER_0_0_29 VGND VGND VPWR VPWR sky130_fd_sc_hd__decap_8
XFILLER_0_8_509 VPWR VGND VPWR VGND sky130_ef_sc_hd__decap_12
XFILLER_0_83_220 VGND VGND VPWR VPWR sky130_fd_sc_hd__decap_4
XFILLER_0_16_309 VGND VGND VPWR VPWR sky130_fd_sc_hd__decap_8
XFILLER_0_9_27 VPWR VGND VPWR VGND sky130_ef_sc_hd__decap_12
X_3610_ _0618_ _0628_ _0630_ _0647_ VGND VGND VPWR VPWR _0648_ sky130_fd_sc_hd__o211a_1
X_4590_ clknet_leaf_9_clock _0396_ VGND VGND VPWR VPWR fifo1.mem\[10\]\[1\] sky130_fd_sc_hd__dfxtp_1
X_3541_ _1772_ _1420_ _1774_ _1775_ fifo3.mem\[11\]\[8\] VGND VGND VPWR VPWR _2101_
+ sky130_fd_sc_hd__o311ai_1
XFILLER_0_10_41 VGND VGND VPWR VPWR sky130_fd_sc_hd__decap_6
X_3472_ _2068_ VGND VGND VPWR VPWR _0549_ sky130_fd_sc_hd__clkbuf_1
X_2423_ _1306_ _1295_ _1307_ VGND VGND VPWR VPWR _1308_ sky130_fd_sc_hd__a21oi_1
X_2354_ _1203_ fifo1.mem\[1\]\[3\] _1240_ VGND VGND VPWR VPWR _1241_ sky130_fd_sc_hd__o21ai_1
X_2285_ net40 net10 VGND VGND VPWR VPWR _1173_ sky130_fd_sc_hd__nand2_2
X_4024_ fifo3.mem\[6\]\[6\] _0944_ _0942_ VGND VGND VPWR VPWR _0951_ sky130_fd_sc_hd__a21bo_1
XFILLER_0_47_423 VPWR VGND VPWR VGND sky130_ef_sc_hd__decap_12
XFILLER_0_74_253 VGND VGND VPWR VPWR sky130_fd_sc_hd__decap_4
XFILLER_0_19_158 VGND VGND VPWR VPWR sky130_fd_sc_hd__decap_8
XFILLER_0_51_81 VPWR VGND VPWR VGND sky130_ef_sc_hd__decap_12
XFILLER_0_74_297 VGND VGND VPWR VPWR sky130_fd_sc_hd__fill_1
X_3808_ fifo3.wr_pointer\[1\] fifo3.wr_pointer\[0\] VGND VGND VPWR VPWR _0802_ sky130_fd_sc_hd__nor2_2
XFILLER_0_34_117 VGND VGND VPWR VPWR sky130_fd_sc_hd__fill_1
X_4788_ clknet_leaf_49_clock _0594_ VGND VGND VPWR VPWR fifo3.mem\[12\]\[7\] sky130_fd_sc_hd__dfxtp_1
X_3739_ fifo1.soft_reset net13 VGND VGND VPWR VPWR _0751_ sky130_fd_sc_hd__nor2b_2
XFILLER_0_85_529 VPWR VGND VPWR VGND sky130_ef_sc_hd__decap_12
XFILLER_0_38_412 VGND VGND VPWR VPWR sky130_fd_sc_hd__decap_8
XFILLER_0_65_297 VGND VGND VPWR VPWR sky130_fd_sc_hd__decap_3
Xclkbuf_leaf_51_clock clknet_3_4__leaf_clock VGND VGND VPWR VPWR clknet_leaf_51_clock
+ sky130_fd_sc_hd__clkbuf_16
XFILLER_0_80_289 VGND VGND VPWR VPWR sky130_fd_sc_hd__fill_2
XTAP_507 VGND VPWR sky130_fd_sc_hd__tapvpwrvgnd_1
XTAP_518 VGND VPWR sky130_fd_sc_hd__tapvpwrvgnd_1
XTAP_529 VGND VPWR sky130_fd_sc_hd__tapvpwrvgnd_1
XFILLER_0_88_345 VPWR VGND VPWR VGND sky130_ef_sc_hd__decap_12
XFILLER_0_88_389 VPWR VGND VPWR VGND sky130_ef_sc_hd__decap_12
X_2972_ _1569_ fifo2.mem\[0\]\[5\] _1570_ VGND VGND VPWR VPWR _1675_ sky130_fd_sc_hd__o21bai_1
XFILLER_0_16_106 VGND VGND VPWR VPWR sky130_fd_sc_hd__decap_3
X_4711_ clknet_leaf_41_clock _0517_ VGND VGND VPWR VPWR net34 sky130_fd_sc_hd__dfxtp_1
XFILLER_0_44_415 VGND VGND VPWR VPWR sky130_fd_sc_hd__decap_4
X_4642_ clknet_leaf_24_clock _0448_ VGND VGND VPWR VPWR fifo2.mem\[6\]\[1\] sky130_fd_sc_hd__dfxtp_1
XFILLER_0_4_501 VPWR VGND VPWR VGND sky130_ef_sc_hd__decap_12
XFILLER_0_44_437 VGND VGND VPWR VPWR sky130_fd_sc_hd__decap_6
Xclkbuf_leaf_19_clock clknet_3_3__leaf_clock VGND VGND VPWR VPWR clknet_leaf_19_clock
+ sky130_fd_sc_hd__clkbuf_16
XFILLER_0_71_278 VGND VGND VPWR VPWR sky130_fd_sc_hd__fill_2
X_4573_ clknet_leaf_56_clock _0379_ VGND VGND VPWR VPWR fifo3.mem\[15\]\[2\] sky130_fd_sc_hd__dfxtp_1
X_3524_ _0939_ _2084_ _2092_ VGND VGND VPWR VPWR _0577_ sky130_fd_sc_hd__a21o_1
X_3455_ _1966_ _1968_ _1975_ _1814_ VGND VGND VPWR VPWR _2056_ sky130_fd_sc_hd__a22o_1
X_2406_ fifo1.count\[3\] net40 _1290_ net10 VGND VGND VPWR VPWR _1291_ sky130_fd_sc_hd__nand4b_1
X_3386_ fifo2.mem\[8\]\[1\] fifo2.mem\[9\]\[1\] fifo2.mem\[10\]\[1\] fifo2.mem\[11\]\[1\]
+ _1669_ _1702_ VGND VGND VPWR VPWR _1999_ sky130_fd_sc_hd__mux4_1
X_2337_ fifo1.mem\[11\]\[2\] _1220_ _1224_ VGND VGND VPWR VPWR _1225_ sky130_fd_sc_hd__o21ai_1
X_2268_ _1155_ _1160_ _1005_ VGND VGND VPWR VPWR _1161_ sky130_fd_sc_hd__o21ai_1
X_4007_ _0939_ _0924_ _0940_ VGND VGND VPWR VPWR _0113_ sky130_fd_sc_hd__a21o_1
XFILLER_0_46_81 VGND VGND VPWR VPWR sky130_fd_sc_hd__decap_3
X_2199_ _0613_ _0749_ _1122_ _1123_ VGND VGND VPWR VPWR _1124_ sky130_fd_sc_hd__and4b_1
XFILLER_0_47_220 VGND VGND VPWR VPWR sky130_fd_sc_hd__decap_4
XFILLER_0_47_275 VGND VGND VPWR VPWR sky130_fd_sc_hd__decap_4
XFILLER_0_7_383 VGND VGND VPWR VPWR sky130_fd_sc_hd__fill_2
XFILLER_0_7_372 VGND VGND VPWR VPWR sky130_fd_sc_hd__decap_6
Xhold41 fifo1.mem\[12\]\[8\] VGND VGND VPWR VPWR net89 sky130_fd_sc_hd__dlygate4sd3_1
Xhold30 fifo2.mem\[3\]\[7\] VGND VGND VPWR VPWR net78 sky130_fd_sc_hd__dlygate4sd3_1
Xhold52 fifo1.mem\[0\]\[2\] VGND VGND VPWR VPWR net100 sky130_fd_sc_hd__dlygate4sd3_1
Xhold74 fifo3.mem\[5\]\[1\] VGND VGND VPWR VPWR net122 sky130_fd_sc_hd__dlygate4sd3_1
XFILLER_0_26_29 VGND VGND VPWR VPWR sky130_fd_sc_hd__decap_6
Xhold63 fifo1.mem\[4\]\[5\] VGND VGND VPWR VPWR net111 sky130_fd_sc_hd__dlygate4sd3_1
Xhold85 fifo1.mem\[13\]\[8\] VGND VGND VPWR VPWR net133 sky130_fd_sc_hd__dlygate4sd3_1
Xhold96 fifo1.mem\[9\]\[6\] VGND VGND VPWR VPWR net144 sky130_fd_sc_hd__dlygate4sd3_1
XFILLER_0_85_337 VPWR VGND VPWR VGND sky130_ef_sc_hd__decap_12
XFILLER_0_53_278 VGND VGND VPWR VPWR sky130_fd_sc_hd__fill_2
XANTENNA_5 _0874_ VGND VGND VPWR VPWR sky130_fd_sc_hd__diode_2
XTAP_315 VGND VPWR sky130_fd_sc_hd__tapvpwrvgnd_1
XTAP_304 VGND VPWR sky130_fd_sc_hd__tapvpwrvgnd_1
XTAP_348 VGND VPWR sky130_fd_sc_hd__tapvpwrvgnd_1
XTAP_337 VGND VPWR sky130_fd_sc_hd__tapvpwrvgnd_1
XTAP_326 VGND VPWR sky130_fd_sc_hd__tapvpwrvgnd_1
X_3240_ _1867_ _1864_ _1868_ VGND VGND VPWR VPWR _1869_ sky130_fd_sc_hd__a21oi_1
X_3171_ net304 _1801_ _1803_ _0797_ VGND VGND VPWR VPWR _0513_ sky130_fd_sc_hd__a22o_1
XTAP_359 VGND VPWR sky130_fd_sc_hd__tapvpwrvgnd_1
X_2122_ fifo2.wr_pointer\[3\] _0619_ _0719_ _1090_ VGND VGND VPWR VPWR _1092_ sky130_fd_sc_hd__and4_1
XFILLER_0_88_197 VPWR VGND VPWR VGND sky130_ef_sc_hd__decap_12
XFILLER_0_57_540 VGND VGND VPWR VPWR sky130_fd_sc_hd__fill_1
XFILLER_0_29_253 VGND VGND VPWR VPWR sky130_fd_sc_hd__fill_2
X_2955_ _1588_ _1616_ _1657_ _1658_ VGND VGND VPWR VPWR _1659_ sky130_fd_sc_hd__nand4_1
X_2886_ fifo2.count\[0\] _1508_ fifo2.count\[1\] VGND VGND VPWR VPWR _1591_ sky130_fd_sc_hd__o21ai_1
X_4625_ clknet_leaf_32_clock _0431_ VGND VGND VPWR VPWR fifo2.rd_pointer\[4\] sky130_fd_sc_hd__dfxtp_2
X_4556_ clknet_leaf_23_clock _0362_ VGND VGND VPWR VPWR fifo2.mem\[2\]\[3\] sky130_fd_sc_hd__dfxtp_1
X_3507_ _2083_ VGND VGND VPWR VPWR _2084_ sky130_fd_sc_hd__buf_2
XFILLER_0_12_164 VPWR VGND VPWR VGND sky130_ef_sc_hd__decap_12
XFILLER_0_12_197 VGND VGND VPWR VPWR sky130_fd_sc_hd__decap_8
X_4487_ clknet_leaf_38_clock _0293_ VGND VGND VPWR VPWR fifo2.mem\[13\]\[6\] sky130_fd_sc_hd__dfxtp_1
X_3438_ fifo3.count\[2\] fifo3.count\[1\] fifo3.count\[0\] _2020_ fifo3.count\[3\]
+ VGND VGND VPWR VPWR _2041_ sky130_fd_sc_hd__o41a_1
XTAP_871 VGND VPWR sky130_fd_sc_hd__tapvpwrvgnd_1
X_3369_ _1409_ _1410_ _1169_ VGND VGND VPWR VPWR _1986_ sky130_fd_sc_hd__and3_1
XTAP_860 VGND VPWR sky130_fd_sc_hd__tapvpwrvgnd_1
XTAP_893 VGND VPWR sky130_fd_sc_hd__tapvpwrvgnd_1
XTAP_882 VGND VPWR sky130_fd_sc_hd__tapvpwrvgnd_1
XFILLER_0_67_337 VGND VGND VPWR VPWR sky130_fd_sc_hd__decap_4
XFILLER_0_82_307 VGND VGND VPWR VPWR sky130_fd_sc_hd__fill_1
XFILLER_0_23_429 VGND VGND VPWR VPWR sky130_fd_sc_hd__decap_3
XFILLER_0_35_267 VPWR VGND VPWR VGND sky130_ef_sc_hd__decap_12
XFILLER_0_35_289 VGND VGND VPWR VPWR sky130_fd_sc_hd__decap_6
XFILLER_0_16_492 VGND VGND VPWR VPWR sky130_fd_sc_hd__fill_1
Xoutput31 net31 VGND VGND VPWR VPWR data_out_2[0] sky130_fd_sc_hd__clkbuf_4
Xoutput42 net42 VGND VGND VPWR VPWR valid_out_2 sky130_fd_sc_hd__clkbuf_4
Xoutput20 net20 VGND VGND VPWR VPWR data_out_0[5] sky130_fd_sc_hd__clkbuf_4
XFILLER_0_37_39 VGND VGND VPWR VPWR sky130_fd_sc_hd__fill_1
XPHY_170 VGND VGND VPWR VPWR sky130_fd_sc_hd__decap_3
XPHY_181 VGND VGND VPWR VPWR sky130_fd_sc_hd__decap_3
XFILLER_0_5_106 VGND VGND VPWR VPWR sky130_fd_sc_hd__decap_6
X_2740_ _1098_ _1488_ _1489_ net168 VGND VGND VPWR VPWR _0396_ sky130_fd_sc_hd__a22o_1
X_2671_ _1110_ _1465_ _1466_ net90 VGND VGND VPWR VPWR _0350_ sky130_fd_sc_hd__a22o_1
XFILLER_0_81_373 VGND VGND VPWR VPWR sky130_fd_sc_hd__decap_8
XFILLER_0_14_407 VGND VGND VPWR VPWR sky130_fd_sc_hd__fill_1
X_4410_ clknet_leaf_10_clock _0224_ VGND VGND VPWR VPWR fifo1.mem\[7\]\[3\] sky130_fd_sc_hd__dfxtp_1
X_4341_ clknet_leaf_43_clock _0155_ VGND VGND VPWR VPWR regis.header_byte\[5\] sky130_fd_sc_hd__dfxtp_1
X_4272_ clknet_leaf_29_clock _0086_ VGND VGND VPWR VPWR syn.count1\[3\] sky130_fd_sc_hd__dfxtp_1
X_3223_ fifo3.mem\[5\]\[2\] VGND VGND VPWR VPWR _1853_ sky130_fd_sc_hd__inv_2
XTAP_189 VGND VPWR sky130_fd_sc_hd__tapvpwrvgnd_1
X_3154_ _0738_ _1152_ _1153_ net322 VGND VGND VPWR VPWR _0500_ sky130_fd_sc_hd__a22o_1
X_3085_ _0760_ _0838_ _1758_ _1763_ VGND VGND VPWR VPWR _0467_ sky130_fd_sc_hd__a31o_1
XFILLER_0_9_401 VGND VGND VPWR VPWR sky130_fd_sc_hd__decap_3
XFILLER_0_49_337 VGND VGND VPWR VPWR sky130_fd_sc_hd__decap_8
XFILLER_0_64_307 VGND VGND VPWR VPWR sky130_fd_sc_hd__fill_1
XFILLER_0_43_93 VPWR VGND VPWR VGND sky130_ef_sc_hd__decap_12
X_3987_ _0733_ VGND VGND VPWR VPWR _0927_ sky130_fd_sc_hd__buf_4
XFILLER_0_91_137 VGND VGND VPWR VPWR sky130_fd_sc_hd__decap_3
XFILLER_0_9_478 VGND VGND VPWR VPWR sky130_fd_sc_hd__fill_2
X_2938_ _1638_ _1639_ _1640_ _1641_ VGND VGND VPWR VPWR _1642_ sky130_fd_sc_hd__o22ai_1
X_2869_ _1544_ _1574_ VGND VGND VPWR VPWR _1575_ sky130_fd_sc_hd__nand2_1
X_4608_ clknet_leaf_5_clock _0414_ VGND VGND VPWR VPWR fifo1.mem\[4\]\[1\] sky130_fd_sc_hd__dfxtp_1
XFILLER_0_40_270 VGND VGND VPWR VPWR sky130_fd_sc_hd__decap_8
X_4539_ clknet_leaf_14_clock _0345_ VGND VGND VPWR VPWR fifo1.mem\[12\]\[4\] sky130_fd_sc_hd__dfxtp_1
XTAP_690 VGND VPWR sky130_fd_sc_hd__tapvpwrvgnd_1
XFILLER_0_67_167 VGND VGND VPWR VPWR sky130_fd_sc_hd__fill_1
XFILLER_0_36_510 VPWR VGND VPWR VGND sky130_ef_sc_hd__decap_12
XFILLER_0_63_362 VPWR VGND VPWR VGND sky130_ef_sc_hd__decap_12
XFILLER_0_31_281 VGND VGND VPWR VPWR sky130_fd_sc_hd__decap_6
XFILLER_0_58_101 VGND VGND VPWR VPWR sky130_fd_sc_hd__fill_2
X_3910_ _0659_ _0674_ _0875_ _0876_ VGND VGND VPWR VPWR _0080_ sky130_fd_sc_hd__o211a_1
XFILLER_0_46_307 VGND VGND VPWR VPWR sky130_fd_sc_hd__fill_1
XFILLER_0_73_126 VGND VGND VPWR VPWR sky130_fd_sc_hd__fill_1
XFILLER_0_73_104 VGND VGND VPWR VPWR sky130_fd_sc_hd__decap_4
X_3841_ _0779_ _0652_ VGND VGND VPWR VPWR _0826_ sky130_fd_sc_hd__nand2_2
X_3772_ fsm1.ld_state fsm1.laf_state fsm1.present_state\[1\] _0646_ VGND VGND VPWR
+ VPWR _0775_ sky130_fd_sc_hd__o31a_4
XFILLER_0_6_448 VGND VGND VPWR VPWR sky130_fd_sc_hd__decap_4
X_2723_ net138 _1481_ _1483_ _0939_ VGND VGND VPWR VPWR _0385_ sky130_fd_sc_hd__a22o_1
X_2654_ _1447_ _1448_ _1450_ _0729_ fifo2.mem\[7\]\[8\] VGND VGND VPWR VPWR _1460_
+ sky130_fd_sc_hd__o311a_1
X_2585_ _0713_ _0869_ _1433_ _1434_ net176 VGND VGND VPWR VPWR _0296_ sky130_fd_sc_hd__a32o_1
X_4324_ clknet_leaf_34_clock _0138_ VGND VGND VPWR VPWR fifo2.mem\[0\]\[6\] sky130_fd_sc_hd__dfxtp_1
XFILLER_0_38_71 VPWR VGND VPWR VGND sky130_ef_sc_hd__decap_12
X_4255_ clknet_leaf_4_clock _0069_ VGND VGND VPWR VPWR fifo3.mem\[1\]\[7\] sky130_fd_sc_hd__dfxtp_1
X_4186_ net3 _1059_ _1035_ _1063_ VGND VGND VPWR VPWR _0169_ sky130_fd_sc_hd__o211a_1
X_3206_ fifo3.mem\[9\]\[2\] _1834_ _1835_ VGND VGND VPWR VPWR _1836_ sky130_fd_sc_hd__o21bai_1
X_3137_ fifo3.mem\[4\]\[5\] _0842_ _1788_ VGND VGND VPWR VPWR _1795_ sky130_fd_sc_hd__a21bo_1
XFILLER_0_89_281 VGND VGND VPWR VPWR sky130_fd_sc_hd__decap_8
X_3068_ _0712_ _1754_ _1756_ _1757_ net56 VGND VGND VPWR VPWR _0456_ sky130_fd_sc_hd__a32o_1
XFILLER_0_49_167 VGND VGND VPWR VPWR sky130_fd_sc_hd__fill_1
XFILLER_0_64_126 VGND VGND VPWR VPWR sky130_fd_sc_hd__fill_1
XFILLER_0_60_321 VGND VGND VPWR VPWR sky130_fd_sc_hd__decap_6
XFILLER_0_5_470 VPWR VGND VPWR VGND sky130_ef_sc_hd__decap_12
XFILLER_0_20_218 VGND VGND VPWR VPWR sky130_fd_sc_hd__fill_1
Xhold160 fifo1.mem\[0\]\[7\] VGND VGND VPWR VPWR net208 sky130_fd_sc_hd__dlygate4sd3_1
Xhold171 fifo1.mem\[1\]\[3\] VGND VGND VPWR VPWR net219 sky130_fd_sc_hd__dlygate4sd3_1
Xhold182 fifo1.mem\[2\]\[6\] VGND VGND VPWR VPWR net230 sky130_fd_sc_hd__dlygate4sd3_1
Xhold193 fifo1.mem\[8\]\[3\] VGND VGND VPWR VPWR net241 sky130_fd_sc_hd__dlygate4sd3_1
XFILLER_0_34_29 VPWR VGND VPWR VGND sky130_ef_sc_hd__decap_12
XFILLER_0_68_421 VGND VGND VPWR VPWR sky130_fd_sc_hd__decap_8
XFILLER_0_36_362 VGND VGND VPWR VPWR sky130_fd_sc_hd__fill_2
XFILLER_0_3_429 VPWR VGND VPWR VGND sky130_ef_sc_hd__decap_12
X_2370_ _1227_ _1256_ VGND VGND VPWR VPWR _1257_ sky130_fd_sc_hd__nand2_1
XFILLER_0_75_36 VPWR VGND VPWR VGND sky130_ef_sc_hd__decap_12
X_4040_ _0722_ VGND VGND VPWR VPWR _0962_ sky130_fd_sc_hd__buf_2
XFILLER_0_19_329 VGND VGND VPWR VPWR sky130_fd_sc_hd__decap_6
XFILLER_0_46_137 VGND VGND VPWR VPWR sky130_fd_sc_hd__decap_3
X_3824_ _0813_ _0737_ _0805_ VGND VGND VPWR VPWR _0814_ sky130_fd_sc_hd__mux2_1
XFILLER_0_6_223 VPWR VGND VPWR VGND sky130_ef_sc_hd__decap_12
X_3755_ _0762_ _0755_ _0758_ net156 VGND VGND VPWR VPWR _0039_ sky130_fd_sc_hd__a22o_1
X_3686_ _0701_ _0707_ _0708_ VGND VGND VPWR VPWR _0709_ sky130_fd_sc_hd__and3b_1
XFILLER_0_42_365 VGND VGND VPWR VPWR sky130_fd_sc_hd__decap_8
X_2706_ net268 _1478_ _1480_ _0930_ VGND VGND VPWR VPWR _0371_ sky130_fd_sc_hd__a22o_1
X_2637_ _0719_ VGND VGND VPWR VPWR _1451_ sky130_fd_sc_hd__clkbuf_4
XFILLER_0_2_462 VPWR VGND VPWR VGND sky130_ef_sc_hd__decap_12
XFILLER_0_64_3 VGND VGND VPWR VPWR sky130_fd_sc_hd__decap_4
X_2568_ _0740_ _1425_ _1429_ _1430_ net181 VGND VGND VPWR VPWR _0283_ sky130_fd_sc_hd__a32o_1
X_2499_ _1176_ fifo1.mem\[14\]\[7\] _1233_ VGND VGND VPWR VPWR _1382_ sky130_fd_sc_hd__o21a_1
X_4307_ clknet_leaf_61_clock _0121_ VGND VGND VPWR VPWR fifo3.mem\[6\]\[7\] sky130_fd_sc_hd__dfxtp_1
X_4238_ clknet_leaf_1_clock _0052_ VGND VGND VPWR VPWR fifo3.mem\[7\]\[8\] sky130_fd_sc_hd__dfxtp_1
XFILLER_0_4_83 VGND VGND VPWR VPWR sky130_fd_sc_hd__fill_1
X_4169_ regis.header_byte\[5\] _0993_ _1040_ net6 VGND VGND VPWR VPWR _1052_ sky130_fd_sc_hd__a22o_1
XFILLER_0_37_137 VPWR VGND VPWR VGND sky130_ef_sc_hd__decap_12
XFILLER_0_65_468 VGND VGND VPWR VPWR sky130_fd_sc_hd__decap_6
XFILLER_0_65_479 VGND VGND VPWR VPWR sky130_fd_sc_hd__decap_4
XFILLER_0_21_538 VGND VGND VPWR VPWR sky130_fd_sc_hd__decap_3
XFILLER_0_56_435 VGND VGND VPWR VPWR sky130_fd_sc_hd__fill_1
XFILLER_0_83_265 VPWR VGND VPWR VGND sky130_ef_sc_hd__decap_12
XFILLER_0_71_449 VGND VGND VPWR VPWR sky130_fd_sc_hd__decap_8
XFILLER_0_9_39 VPWR VGND VPWR VGND sky130_ef_sc_hd__decap_12
X_3540_ _0744_ _2094_ _2098_ net129 VGND VGND VPWR VPWR _0585_ sky130_fd_sc_hd__a22o_1
XFILLER_0_12_505 VPWR VGND VPWR VGND sky130_ef_sc_hd__decap_12
XFILLER_0_10_53 VPWR VGND VPWR VGND sky130_ef_sc_hd__decap_12
XFILLER_0_51_151 VPWR VGND VPWR VGND sky130_ef_sc_hd__decap_12
X_3471_ _1164_ _1165_ _1169_ VGND VGND VPWR VPWR _2068_ sky130_fd_sc_hd__and3_1
X_2422_ _1296_ fifo1.mem\[2\]\[5\] _1178_ VGND VGND VPWR VPWR _1307_ sky130_fd_sc_hd__o21ai_1
X_2353_ _1221_ fifo1.mem\[0\]\[3\] _1177_ VGND VGND VPWR VPWR _1240_ sky130_fd_sc_hd__o21ba_1
X_4023_ _0934_ _0943_ _0950_ VGND VGND VPWR VPWR _0119_ sky130_fd_sc_hd__o21a_1
X_2284_ fifo1.rd_pointer\[4\] _1168_ _1172_ VGND VGND VPWR VPWR _0257_ sky130_fd_sc_hd__a21oi_1
XFILLER_0_79_505 VPWR VGND VPWR VGND sky130_ef_sc_hd__decap_12
XFILLER_0_74_210 VGND VGND VPWR VPWR sky130_fd_sc_hd__decap_3
XFILLER_0_47_435 VGND VGND VPWR VPWR sky130_fd_sc_hd__decap_4
X_3807_ _0799_ fifo3.mem\[8\]\[0\] _0800_ VGND VGND VPWR VPWR _0801_ sky130_fd_sc_hd__and3_1
XFILLER_0_51_93 VGND VGND VPWR VPWR sky130_fd_sc_hd__decap_3
X_4787_ clknet_leaf_49_clock _0593_ VGND VGND VPWR VPWR fifo3.mem\[12\]\[6\] sky130_fd_sc_hd__dfxtp_1
XFILLER_0_27_181 VPWR VGND VPWR VGND sky130_ef_sc_hd__decap_12
X_3738_ _0613_ _0749_ VGND VGND VPWR VPWR _0750_ sky130_fd_sc_hd__nor2_2
XFILLER_0_70_460 VGND VGND VPWR VPWR sky130_fd_sc_hd__fill_2
X_3669_ net10 VGND VGND VPWR VPWR _0696_ sky130_fd_sc_hd__inv_2
XFILLER_0_65_210 VGND VGND VPWR VPWR sky130_fd_sc_hd__decap_4
XFILLER_0_80_213 VPWR VGND VPWR VGND sky130_ef_sc_hd__decap_12
XFILLER_0_18_170 VGND VGND VPWR VPWR sky130_fd_sc_hd__fill_1
XFILLER_0_61_460 VGND VGND VPWR VPWR sky130_fd_sc_hd__decap_3
XTAP_508 VGND VPWR sky130_fd_sc_hd__tapvpwrvgnd_1
XTAP_519 VGND VPWR sky130_fd_sc_hd__tapvpwrvgnd_1
XFILLER_0_88_357 VGND VGND VPWR VPWR sky130_fd_sc_hd__decap_6
XFILLER_0_8_318 VGND VGND VPWR VPWR sky130_fd_sc_hd__decap_6
X_2971_ fifo2.mem\[3\]\[5\] _1556_ VGND VGND VPWR VPWR _1674_ sky130_fd_sc_hd__and2b_1
X_4710_ clknet_leaf_25_clock _0516_ VGND VGND VPWR VPWR net33 sky130_fd_sc_hd__dfxtp_1
X_4641_ clknet_leaf_24_clock _0447_ VGND VGND VPWR VPWR fifo2.mem\[6\]\[0\] sky130_fd_sc_hd__dfxtp_1
XFILLER_0_44_449 VPWR VGND VPWR VGND sky130_ef_sc_hd__decap_12
XFILLER_0_4_513 VPWR VGND VPWR VGND sky130_ef_sc_hd__decap_12
XFILLER_0_21_63 VGND VGND VPWR VPWR sky130_fd_sc_hd__fill_1
XFILLER_0_12_302 VGND VGND VPWR VPWR sky130_fd_sc_hd__decap_6
X_4572_ clknet_leaf_48_clock _0378_ VGND VGND VPWR VPWR fifo3.mem\[15\]\[1\] sky130_fd_sc_hd__dfxtp_1
XFILLER_0_24_151 VPWR VGND VPWR VGND sky130_ef_sc_hd__decap_12
X_3523_ _1760_ _0840_ _1773_ fifo3.mem\[10\]\[8\] _0944_ VGND VGND VPWR VPWR _2092_
+ sky130_fd_sc_hd__o311a_1
X_3454_ _2052_ _2055_ _0921_ VGND VGND VPWR VPWR _0544_ sky130_fd_sc_hd__a21oi_1
X_2405_ fifo1.count\[2\] fifo1.count\[1\] fifo1.count\[0\] VGND VGND VPWR VPWR _1290_
+ sky130_fd_sc_hd__nor3_1
X_3385_ _1996_ _1997_ _1547_ VGND VGND VPWR VPWR _1998_ sky130_fd_sc_hd__mux2_1
X_2336_ _1221_ fifo1.mem\[10\]\[2\] _1182_ VGND VGND VPWR VPWR _1224_ sky130_fd_sc_hd__o21a_1
X_2267_ _1159_ VGND VGND VPWR VPWR _1160_ sky130_fd_sc_hd__buf_2
X_4006_ _0928_ _0786_ fifo3.mem\[5\]\[8\] VGND VGND VPWR VPWR _0940_ sky130_fd_sc_hd__and3_1
XFILLER_0_27_3 VPWR VGND VPWR VGND sky130_ef_sc_hd__decap_12
X_2198_ fifo1.wr_pointer\[1\] fifo1.wr_pointer\[0\] VGND VGND VPWR VPWR _1123_ sky130_fd_sc_hd__and2_2
XFILLER_0_1_51 VGND VGND VPWR VPWR sky130_fd_sc_hd__decap_4
XFILLER_0_47_243 VGND VGND VPWR VPWR sky130_fd_sc_hd__fill_2
XFILLER_0_90_533 VGND VGND VPWR VPWR sky130_fd_sc_hd__decap_4
XFILLER_0_35_449 VGND VGND VPWR VPWR sky130_fd_sc_hd__decap_6
Xhold31 fifo2.mem\[0\]\[1\] VGND VGND VPWR VPWR net79 sky130_fd_sc_hd__dlygate4sd3_1
Xhold20 fifo2.mem\[3\]\[8\] VGND VGND VPWR VPWR net68 sky130_fd_sc_hd__dlygate4sd3_1
Xhold42 fifo1.mem\[13\]\[0\] VGND VGND VPWR VPWR net90 sky130_fd_sc_hd__dlygate4sd3_1
Xhold64 fifo1.mem\[12\]\[6\] VGND VGND VPWR VPWR net112 sky130_fd_sc_hd__dlygate4sd3_1
Xhold53 fifo3.mem\[3\]\[0\] VGND VGND VPWR VPWR net101 sky130_fd_sc_hd__dlygate4sd3_1
Xhold75 fifo3.mem\[5\]\[7\] VGND VGND VPWR VPWR net123 sky130_fd_sc_hd__dlygate4sd3_1
Xhold86 fifo3.mem\[12\]\[8\] VGND VGND VPWR VPWR net134 sky130_fd_sc_hd__dlygate4sd3_1
Xhold97 fifo1.mem\[4\]\[6\] VGND VGND VPWR VPWR net145 sky130_fd_sc_hd__dlygate4sd3_1
XFILLER_0_85_349 VPWR VGND VPWR VGND sky130_ef_sc_hd__decap_12
XFILLER_0_42_29 VPWR VGND VPWR VGND sky130_ef_sc_hd__decap_12
XFILLER_0_38_276 VPWR VGND VPWR VGND sky130_ef_sc_hd__decap_12
XFILLER_0_26_449 VGND VGND VPWR VPWR sky130_fd_sc_hd__decap_3
XFILLER_0_1_505 VPWR VGND VPWR VGND sky130_ef_sc_hd__decap_12
XFILLER_0_34_493 VPWR VGND VPWR VGND sky130_ef_sc_hd__decap_12
XANTENNA_6 _1703_ VGND VGND VPWR VPWR sky130_fd_sc_hd__diode_2
XFILLER_0_6_29 VPWR VGND VPWR VGND sky130_ef_sc_hd__decap_12
XTAP_305 VGND VPWR sky130_fd_sc_hd__tapvpwrvgnd_1
XTAP_349 VGND VPWR sky130_fd_sc_hd__tapvpwrvgnd_1
XTAP_338 VGND VPWR sky130_fd_sc_hd__tapvpwrvgnd_1
XTAP_327 VGND VPWR sky130_fd_sc_hd__tapvpwrvgnd_1
XTAP_316 VGND VPWR sky130_fd_sc_hd__tapvpwrvgnd_1
X_3170_ net196 _1801_ _1803_ _0766_ VGND VGND VPWR VPWR _0512_ sky130_fd_sc_hd__a22o_1
X_2121_ fifo2.wr_pointer\[3\] _0619_ _1090_ _0974_ VGND VGND VPWR VPWR _1091_ sky130_fd_sc_hd__a31oi_4
XFILLER_0_88_121 VGND VGND VPWR VPWR sky130_fd_sc_hd__decap_3
XFILLER_0_16_85 VGND VGND VPWR VPWR sky130_fd_sc_hd__decap_6
X_2954_ _1637_ _1643_ _0007_ VGND VGND VPWR VPWR _1658_ sky130_fd_sc_hd__nand3_1
X_2885_ _1554_ _1588_ _1589_ _1590_ _0974_ VGND VGND VPWR VPWR _0440_ sky130_fd_sc_hd__a221oi_1
XFILLER_0_72_533 VGND VGND VPWR VPWR sky130_fd_sc_hd__fill_2
XFILLER_0_17_449 VGND VGND VPWR VPWR sky130_fd_sc_hd__decap_6
XFILLER_0_32_419 VGND VGND VPWR VPWR sky130_fd_sc_hd__fill_1
X_4624_ clknet_leaf_32_clock _0430_ VGND VGND VPWR VPWR fifo2.rd_pointer\[3\] sky130_fd_sc_hd__dfxtp_2
XFILLER_0_4_365 VPWR VGND VPWR VGND sky130_ef_sc_hd__decap_12
X_4555_ clknet_leaf_23_clock _0361_ VGND VGND VPWR VPWR fifo2.mem\[2\]\[2\] sky130_fd_sc_hd__dfxtp_1
X_3506_ _0770_ _0781_ _0803_ _1758_ VGND VGND VPWR VPWR _2083_ sky130_fd_sc_hd__and4b_1
X_4486_ clknet_leaf_37_clock _0292_ VGND VGND VPWR VPWR fifo2.mem\[13\]\[5\] sky130_fd_sc_hd__dfxtp_1
X_3437_ _2035_ _2038_ _2040_ VGND VGND VPWR VPWR _0542_ sky130_fd_sc_hd__a21oi_1
X_3368_ _1985_ VGND VGND VPWR VPWR _0528_ sky130_fd_sc_hd__clkbuf_1
XTAP_850 VGND VPWR sky130_fd_sc_hd__tapvpwrvgnd_1
XTAP_861 VGND VPWR sky130_fd_sc_hd__tapvpwrvgnd_1
XTAP_894 VGND VPWR sky130_fd_sc_hd__tapvpwrvgnd_1
XTAP_883 VGND VPWR sky130_fd_sc_hd__tapvpwrvgnd_1
XTAP_872 VGND VPWR sky130_fd_sc_hd__tapvpwrvgnd_1
XFILLER_0_57_92 VPWR VGND VPWR VGND sky130_ef_sc_hd__decap_12
X_2319_ fifo1.mem\[7\]\[2\] _1203_ _1206_ VGND VGND VPWR VPWR _1207_ sky130_fd_sc_hd__o21ai_1
X_3299_ _1832_ fifo3.mem\[0\]\[5\] _1857_ VGND VGND VPWR VPWR _1926_ sky130_fd_sc_hd__o21bai_1
Xclkbuf_leaf_50_clock clknet_3_4__leaf_clock VGND VGND VPWR VPWR clknet_leaf_50_clock
+ sky130_fd_sc_hd__clkbuf_16
XFILLER_0_63_522 VGND VGND VPWR VPWR sky130_fd_sc_hd__fill_1
XFILLER_0_90_363 VGND VGND VPWR VPWR sky130_fd_sc_hd__fill_1
XFILLER_0_35_279 VGND VGND VPWR VPWR sky130_fd_sc_hd__fill_1
Xoutput32 net32 VGND VGND VPWR VPWR data_out_2[1] sky130_fd_sc_hd__clkbuf_4
Xoutput21 net21 VGND VGND VPWR VPWR data_out_0[6] sky130_fd_sc_hd__clkbuf_4
Xclkbuf_leaf_18_clock clknet_3_3__leaf_clock VGND VGND VPWR VPWR clknet_leaf_18_clock
+ sky130_fd_sc_hd__clkbuf_16
XPHY_160 VGND VGND VPWR VPWR sky130_fd_sc_hd__decap_3
XFILLER_0_66_371 VPWR VGND VPWR VGND sky130_ef_sc_hd__decap_12
XPHY_182 VGND VGND VPWR VPWR sky130_fd_sc_hd__decap_3
XPHY_171 VGND VGND VPWR VPWR sky130_fd_sc_hd__decap_3
XFILLER_0_66_393 VPWR VGND VPWR VGND sky130_ef_sc_hd__decap_12
X_2670_ _1102_ _1465_ VGND VGND VPWR VPWR _1466_ sky130_fd_sc_hd__nor2_4
XFILLER_0_5_129 VPWR VGND VPWR VGND sky130_ef_sc_hd__decap_12
X_4340_ clknet_leaf_43_clock _0154_ VGND VGND VPWR VPWR regis.header_byte\[4\] sky130_fd_sc_hd__dfxtp_1
X_4271_ clknet_leaf_29_clock _0085_ VGND VGND VPWR VPWR syn.count1\[2\] sky130_fd_sc_hd__dfxtp_1
X_3222_ _1847_ _1848_ _1850_ _1851_ VGND VGND VPWR VPWR _1852_ sky130_fd_sc_hd__o22a_1
X_3153_ _0736_ _1152_ _1153_ net288 VGND VGND VPWR VPWR _0499_ sky130_fd_sc_hd__a22o_1
X_3084_ _1760_ _1419_ _0835_ _0782_ fifo3.mem\[2\]\[2\] VGND VGND VPWR VPWR _1763_
+ sky130_fd_sc_hd__o311a_1
XFILLER_0_76_102 VGND VGND VPWR VPWR sky130_fd_sc_hd__fill_2
XFILLER_0_9_413 VGND VGND VPWR VPWR sky130_fd_sc_hd__decap_8
XFILLER_0_91_105 VGND VGND VPWR VPWR sky130_fd_sc_hd__fill_1
X_3986_ net122 _0922_ _0924_ _0926_ VGND VGND VPWR VPWR _0106_ sky130_fd_sc_hd__a22o_1
X_2937_ fifo2.mem\[9\]\[4\] _1567_ VGND VGND VPWR VPWR _1641_ sky130_fd_sc_hd__and2b_1
XFILLER_0_32_227 VGND VGND VPWR VPWR sky130_fd_sc_hd__decap_6
X_4607_ clknet_leaf_8_clock _0413_ VGND VGND VPWR VPWR fifo1.mem\[4\]\[0\] sky130_fd_sc_hd__dfxtp_1
X_2868_ _1566_ _1568_ _1571_ _1573_ VGND VGND VPWR VPWR _1574_ sky130_fd_sc_hd__o22ai_1
XFILLER_0_13_430 VPWR VGND VPWR VGND sky130_ef_sc_hd__decap_12
X_2799_ fifo2.rd_pointer\[3\] _1513_ _1514_ VGND VGND VPWR VPWR _0430_ sky130_fd_sc_hd__a21oi_1
XFILLER_0_13_485 VGND VGND VPWR VPWR sky130_fd_sc_hd__fill_2
XFILLER_0_4_195 VGND VGND VPWR VPWR sky130_fd_sc_hd__fill_1
X_4538_ clknet_leaf_19_clock _0344_ VGND VGND VPWR VPWR fifo1.mem\[12\]\[3\] sky130_fd_sc_hd__dfxtp_1
X_4469_ clknet_leaf_3_clock _0275_ VGND VGND VPWR VPWR fifo3.mem\[3\]\[6\] sky130_fd_sc_hd__dfxtp_1
XFILLER_0_40_293 VGND VGND VPWR VPWR sky130_fd_sc_hd__decap_3
XTAP_680 VGND VPWR sky130_fd_sc_hd__tapvpwrvgnd_1
XTAP_691 VGND VPWR sky130_fd_sc_hd__tapvpwrvgnd_1
XFILLER_0_36_522 VGND VGND VPWR VPWR sky130_fd_sc_hd__decap_8
XFILLER_0_36_533 VGND VGND VPWR VPWR sky130_fd_sc_hd__decap_8
XFILLER_0_63_341 VGND VGND VPWR VPWR sky130_fd_sc_hd__fill_1
XFILLER_0_63_374 VGND VGND VPWR VPWR sky130_fd_sc_hd__fill_1
XFILLER_0_23_238 VGND VGND VPWR VPWR sky130_fd_sc_hd__fill_1
XFILLER_0_80_37 VGND VGND VPWR VPWR sky130_fd_sc_hd__decap_8
XFILLER_0_86_477 VPWR VGND VPWR VGND sky130_ef_sc_hd__decap_12
X_3840_ _0824_ VGND VGND VPWR VPWR _0825_ sky130_fd_sc_hd__clkbuf_4
XFILLER_0_6_405 VPWR VGND VPWR VGND sky130_ef_sc_hd__decap_12
X_3771_ _0641_ _0642_ _0643_ _0644_ VGND VGND VPWR VPWR _0774_ sky130_fd_sc_hd__o211ai_4
XFILLER_0_13_97 VGND VGND VPWR VPWR sky130_fd_sc_hd__decap_8
X_2722_ net261 _1481_ _1483_ _0938_ VGND VGND VPWR VPWR _0384_ sky130_fd_sc_hd__a22o_1
XFILLER_0_54_341 VPWR VGND VPWR VGND sky130_ef_sc_hd__decap_12
XFILLER_0_89_57 VPWR VGND VPWR VGND sky130_ef_sc_hd__decap_12
XFILLER_0_80_9 VGND VGND VPWR VPWR sky130_fd_sc_hd__decap_8
XFILLER_0_54_385 VGND VGND VPWR VPWR sky130_fd_sc_hd__fill_1
X_2653_ _0766_ _0856_ _1446_ _1459_ VGND VGND VPWR VPWR _0339_ sky130_fd_sc_hd__a31o_1
XFILLER_0_10_411 VGND VGND VPWR VPWR sky130_fd_sc_hd__decap_3
X_2584_ _0851_ _1427_ _0974_ VGND VGND VPWR VPWR _1434_ sky130_fd_sc_hd__a21oi_4
X_4323_ clknet_leaf_33_clock _0137_ VGND VGND VPWR VPWR fifo2.mem\[0\]\[5\] sky130_fd_sc_hd__dfxtp_1
X_4254_ clknet_leaf_3_clock _0068_ VGND VGND VPWR VPWR fifo3.mem\[1\]\[6\] sky130_fd_sc_hd__dfxtp_1
X_4185_ regis.packet_parity\[2\] _0682_ VGND VGND VPWR VPWR _1063_ sky130_fd_sc_hd__or2_1
X_3205_ _0009_ VGND VGND VPWR VPWR _1835_ sky130_fd_sc_hd__clkbuf_4
XFILLER_0_38_83 VGND VGND VPWR VPWR sky130_fd_sc_hd__fill_1
X_3136_ _0932_ _1789_ _1794_ VGND VGND VPWR VPWR _0487_ sky130_fd_sc_hd__o21a_1
X_3067_ _0803_ _1756_ _0921_ VGND VGND VPWR VPWR _1757_ sky130_fd_sc_hd__a21oi_4
XFILLER_0_77_400 VGND VGND VPWR VPWR sky130_fd_sc_hd__fill_2
XFILLER_0_9_221 VGND VGND VPWR VPWR sky130_fd_sc_hd__decap_3
XFILLER_0_18_500 VPWR VGND VPWR VGND sky130_ef_sc_hd__decap_12
XFILLER_0_18_533 VGND VGND VPWR VPWR sky130_fd_sc_hd__decap_8
XFILLER_0_64_149 VGND VGND VPWR VPWR sky130_fd_sc_hd__fill_2
X_3969_ net5 regis.fifo_full_state\[4\] _0910_ VGND VGND VPWR VPWR _0915_ sky130_fd_sc_hd__mux2_1
XFILLER_0_45_374 VGND VGND VPWR VPWR sky130_fd_sc_hd__fill_1
XFILLER_0_5_482 VPWR VGND VPWR VGND sky130_ef_sc_hd__decap_12
XFILLER_0_13_260 VGND VGND VPWR VPWR sky130_fd_sc_hd__decap_3
XFILLER_0_60_399 VGND VGND VPWR VPWR sky130_fd_sc_hd__fill_1
Xhold150 fifo1.mem\[13\]\[1\] VGND VGND VPWR VPWR net198 sky130_fd_sc_hd__dlygate4sd3_1
Xhold161 fifo3.mem\[0\]\[8\] VGND VGND VPWR VPWR net209 sky130_fd_sc_hd__dlygate4sd3_1
Xhold194 fifo1.mem\[2\]\[5\] VGND VGND VPWR VPWR net242 sky130_fd_sc_hd__dlygate4sd3_1
Xhold183 fifo1.mem\[1\]\[2\] VGND VGND VPWR VPWR net231 sky130_fd_sc_hd__dlygate4sd3_1
Xhold172 fifo2.mem\[12\]\[8\] VGND VGND VPWR VPWR net220 sky130_fd_sc_hd__dlygate4sd3_1
XFILLER_0_83_447 VGND VGND VPWR VPWR sky130_fd_sc_hd__fill_1
XFILLER_0_50_29 VGND VGND VPWR VPWR sky130_fd_sc_hd__fill_1
XFILLER_0_75_15 VGND VGND VPWR VPWR sky130_fd_sc_hd__decap_8
XFILLER_0_75_48 VGND VGND VPWR VPWR sky130_fd_sc_hd__decap_8
XFILLER_0_24_85 VPWR VGND VPWR VGND sky130_ef_sc_hd__decap_12
X_3823_ _0779_ fifo3.mem\[8\]\[4\] _0800_ VGND VGND VPWR VPWR _0813_ sky130_fd_sc_hd__and3_1
XFILLER_0_6_235 VGND VGND VPWR VPWR sky130_fd_sc_hd__fill_2
X_3754_ _0737_ VGND VGND VPWR VPWR _0762_ sky130_fd_sc_hd__buf_4
X_3685_ syn.count0\[3\] syn.count0\[4\] _0703_ VGND VGND VPWR VPWR _0708_ sky130_fd_sc_hd__nand3_1
XFILLER_0_6_279 VGND VGND VPWR VPWR sky130_fd_sc_hd__decap_8
X_2705_ net346 _1478_ _1480_ _0927_ VGND VGND VPWR VPWR _0370_ sky130_fd_sc_hd__a22o_1
X_2636_ _1449_ VGND VGND VPWR VPWR _1450_ sky130_fd_sc_hd__buf_2
XFILLER_0_2_474 VGND VGND VPWR VPWR sky130_fd_sc_hd__fill_2
XFILLER_0_10_241 VGND VGND VPWR VPWR sky130_fd_sc_hd__decap_8
X_2567_ _0738_ _1425_ _1429_ _1430_ net161 VGND VGND VPWR VPWR _0282_ sky130_fd_sc_hd__a32o_1
XFILLER_0_57_3 VGND VGND VPWR VPWR sky130_fd_sc_hd__fill_2
X_2498_ _1320_ fifo1.mem\[13\]\[7\] _1380_ VGND VGND VPWR VPWR _1381_ sky130_fd_sc_hd__o21ai_1
X_4306_ clknet_leaf_0_clock _0120_ VGND VGND VPWR VPWR fifo3.mem\[6\]\[6\] sky130_fd_sc_hd__dfxtp_1
X_4237_ clknet_leaf_1_clock _0051_ VGND VGND VPWR VPWR fifo3.mem\[7\]\[7\] sky130_fd_sc_hd__dfxtp_1
X_4168_ regis.internal_parity\[4\] _1050_ _1051_ VGND VGND VPWR VPWR _0163_ sky130_fd_sc_hd__o21a_1
X_3119_ _0839_ _1779_ _1781_ fifo3.mem\[9\]\[6\] _1783_ VGND VGND VPWR VPWR _1785_
+ sky130_fd_sc_hd__o311a_1
X_4099_ net3 _0986_ _0989_ _1001_ VGND VGND VPWR VPWR _1002_ sky130_fd_sc_hd__o211ai_1
XFILLER_0_77_285 VGND VGND VPWR VPWR sky130_fd_sc_hd__fill_1
XFILLER_0_37_149 VGND VGND VPWR VPWR sky130_fd_sc_hd__decap_3
XFILLER_0_65_436 VGND VGND VPWR VPWR sky130_fd_sc_hd__decap_3
XFILLER_0_18_352 VGND VGND VPWR VPWR sky130_fd_sc_hd__decap_3
XFILLER_0_18_374 VGND VGND VPWR VPWR sky130_fd_sc_hd__fill_2
XFILLER_0_18_385 VGND VGND VPWR VPWR sky130_fd_sc_hd__decap_8
XFILLER_0_45_182 VPWR VGND VPWR VGND sky130_ef_sc_hd__decap_12
XFILLER_0_5_290 VGND VGND VPWR VPWR sky130_fd_sc_hd__decap_4
XFILLER_0_83_200 VGND VGND VPWR VPWR sky130_fd_sc_hd__decap_4
XFILLER_0_28_105 VGND VGND VPWR VPWR sky130_fd_sc_hd__fill_1
XFILLER_0_28_149 VPWR VGND VPWR VGND sky130_ef_sc_hd__decap_12
XFILLER_0_83_277 VGND VGND VPWR VPWR sky130_fd_sc_hd__decap_3
XFILLER_0_12_517 VPWR VGND VPWR VGND sky130_ef_sc_hd__decap_12
XFILLER_0_51_163 VGND VGND VPWR VPWR sky130_fd_sc_hd__decap_4
XFILLER_0_10_65 VPWR VGND VPWR VGND sky130_ef_sc_hd__decap_12
X_3470_ fifo1.rd_pointer\[1\] _1155_ _1160_ _1163_ VGND VGND VPWR VPWR _0548_ sky130_fd_sc_hd__a31oi_1
X_2421_ fifo1.mem\[3\]\[5\] VGND VGND VPWR VPWR _1306_ sky130_fd_sc_hd__inv_2
XFILLER_0_86_69 VPWR VGND VPWR VGND sky130_ef_sc_hd__decap_12
X_2352_ _1238_ _1185_ _0003_ VGND VGND VPWR VPWR _1239_ sky130_fd_sc_hd__a21oi_2
XFILLER_0_19_52 VGND VGND VPWR VPWR sky130_fd_sc_hd__decap_4
X_2283_ fifo1.rd_pointer\[4\] _1168_ _1005_ VGND VGND VPWR VPWR _1172_ sky130_fd_sc_hd__o21ai_1
X_4022_ fifo3.mem\[6\]\[5\] _0944_ _0942_ VGND VGND VPWR VPWR _0950_ sky130_fd_sc_hd__a21bo_1
XFILLER_0_79_517 VPWR VGND VPWR VGND sky130_ef_sc_hd__decap_12
XFILLER_0_35_62 VPWR VGND VPWR VGND sky130_ef_sc_hd__decap_12
XFILLER_0_59_263 VGND VGND VPWR VPWR sky130_fd_sc_hd__decap_8
X_4786_ clknet_leaf_47_clock _0592_ VGND VGND VPWR VPWR fifo3.mem\[12\]\[5\] sky130_fd_sc_hd__dfxtp_1
X_3806_ _0652_ VGND VGND VPWR VPWR _0800_ sky130_fd_sc_hd__buf_2
XFILLER_0_62_417 VGND VGND VPWR VPWR sky130_fd_sc_hd__decap_3
XFILLER_0_27_193 VGND VGND VPWR VPWR sky130_fd_sc_hd__decap_6
X_3737_ fifo1.wr_pointer\[2\] VGND VGND VPWR VPWR _0749_ sky130_fd_sc_hd__clkbuf_4
XFILLER_0_15_388 VGND VGND VPWR VPWR sky130_fd_sc_hd__decap_4
XFILLER_0_15_377 VGND VGND VPWR VPWR sky130_fd_sc_hd__decap_4
XFILLER_0_30_303 VGND VGND VPWR VPWR sky130_fd_sc_hd__decap_4
XFILLER_0_42_141 VGND VGND VPWR VPWR sky130_fd_sc_hd__decap_6
XFILLER_0_15_399 VGND VGND VPWR VPWR sky130_fd_sc_hd__fill_1
X_3668_ fsm1.rst_int_reg _0681_ fsm1.full_state _0654_ _0678_ VGND VGND VPWR VPWR
+ _0012_ sky130_fd_sc_hd__o311a_1
X_3599_ fifo3.rd_pointer\[0\] VGND VGND VPWR VPWR _0637_ sky130_fd_sc_hd__buf_2
X_2619_ _0859_ _0972_ _0725_ _0851_ VGND VGND VPWR VPWR _1442_ sky130_fd_sc_hd__nand4_4
XFILLER_0_65_222 VGND VGND VPWR VPWR sky130_fd_sc_hd__fill_2
XFILLER_0_80_225 VGND VGND VPWR VPWR sky130_fd_sc_hd__decap_4
XFILLER_0_25_108 VGND VGND VPWR VPWR sky130_fd_sc_hd__decap_4
XFILLER_0_80_258 VGND VGND VPWR VPWR sky130_fd_sc_hd__fill_2
XFILLER_0_18_193 VGND VGND VPWR VPWR sky130_fd_sc_hd__decap_3
XFILLER_0_80_269 VPWR VGND VPWR VGND sky130_ef_sc_hd__decap_12
XFILLER_0_61_472 VGND VGND VPWR VPWR sky130_fd_sc_hd__fill_1
XTAP_509 VGND VPWR sky130_fd_sc_hd__tapvpwrvgnd_1
XFILLER_0_84_531 VGND VGND VPWR VPWR sky130_fd_sc_hd__fill_1
XFILLER_0_29_414 VGND VGND VPWR VPWR sky130_fd_sc_hd__decap_3
XFILLER_0_29_425 VGND VGND VPWR VPWR sky130_fd_sc_hd__fill_2
XFILLER_0_29_447 VGND VGND VPWR VPWR sky130_fd_sc_hd__fill_1
X_2970_ _1550_ fifo2.mem\[2\]\[5\] _1562_ VGND VGND VPWR VPWR _1673_ sky130_fd_sc_hd__o21ai_1
XFILLER_0_71_225 VPWR VGND VPWR VGND sky130_ef_sc_hd__decap_12
X_4640_ clknet_leaf_31_clock _0446_ VGND VGND VPWR VPWR fifo2.count\[6\] sky130_fd_sc_hd__dfxtp_1
XFILLER_0_4_525 VGND VGND VPWR VPWR sky130_fd_sc_hd__decap_6
X_4571_ clknet_leaf_56_clock _0377_ VGND VGND VPWR VPWR fifo3.mem\[15\]\[0\] sky130_fd_sc_hd__dfxtp_1
XFILLER_0_21_97 VGND VGND VPWR VPWR sky130_fd_sc_hd__decap_3
XFILLER_0_24_163 VGND VGND VPWR VPWR sky130_fd_sc_hd__decap_4
X_3522_ _0938_ _2084_ _2091_ VGND VGND VPWR VPWR _0576_ sky130_fd_sc_hd__a21o_1
X_3453_ _2053_ _2032_ _2046_ _2054_ _2019_ VGND VGND VPWR VPWR _2055_ sky130_fd_sc_hd__o311ai_1
X_2404_ fifo1.count\[2\] _1259_ _1195_ _1121_ _1289_ VGND VGND VPWR VPWR _0260_ sky130_fd_sc_hd__o311a_1
X_3384_ fifo2.mem\[0\]\[1\] fifo2.mem\[1\]\[1\] fifo2.mem\[2\]\[1\] fifo2.mem\[3\]\[1\]
+ _1669_ _1702_ VGND VGND VPWR VPWR _1997_ sky130_fd_sc_hd__mux4_1
X_2335_ _1220_ fifo1.mem\[9\]\[2\] _1222_ VGND VGND VPWR VPWR _1223_ sky130_fd_sc_hd__o21ai_1
X_2266_ fifo1.soft_reset _0617_ _1158_ net10 VGND VGND VPWR VPWR _1159_ sky130_fd_sc_hd__and4b_1
XFILLER_0_79_303 VGND VGND VPWR VPWR sky130_fd_sc_hd__decap_3
X_4005_ _0767_ VGND VGND VPWR VPWR _0939_ sky130_fd_sc_hd__buf_4
X_2197_ _1111_ VGND VGND VPWR VPWR _1122_ sky130_fd_sc_hd__buf_4
XFILLER_0_87_391 VGND VGND VPWR VPWR sky130_fd_sc_hd__fill_1
XFILLER_0_1_96 VPWR VGND VPWR VGND sky130_ef_sc_hd__decap_12
XFILLER_0_47_211 VGND VGND VPWR VPWR sky130_fd_sc_hd__decap_3
XFILLER_0_90_501 VPWR VGND VPWR VGND sky130_ef_sc_hd__decap_12
XFILLER_0_62_203 VGND VGND VPWR VPWR sky130_fd_sc_hd__decap_3
XFILLER_0_7_352 VGND VGND VPWR VPWR sky130_fd_sc_hd__decap_3
X_4769_ clknet_leaf_59_clock _0575_ VGND VGND VPWR VPWR fifo3.mem\[10\]\[6\] sky130_fd_sc_hd__dfxtp_1
Xhold10 fifo3.mem\[12\]\[0\] VGND VGND VPWR VPWR net58 sky130_fd_sc_hd__dlygate4sd3_1
Xhold21 fifo3.mem\[13\]\[7\] VGND VGND VPWR VPWR net69 sky130_fd_sc_hd__dlygate4sd3_1
Xhold32 fifo2.mem\[11\]\[0\] VGND VGND VPWR VPWR net80 sky130_fd_sc_hd__dlygate4sd3_1
Xhold43 fifo3.mem\[10\]\[2\] VGND VGND VPWR VPWR net91 sky130_fd_sc_hd__dlygate4sd3_1
Xhold65 fifo1.mem\[9\]\[1\] VGND VGND VPWR VPWR net113 sky130_fd_sc_hd__dlygate4sd3_1
Xhold54 fifo2.mem\[13\]\[4\] VGND VGND VPWR VPWR net102 sky130_fd_sc_hd__dlygate4sd3_1
Xhold76 fifo1.mem\[14\]\[0\] VGND VGND VPWR VPWR net124 sky130_fd_sc_hd__dlygate4sd3_1
Xhold98 fifo3.mem\[12\]\[1\] VGND VGND VPWR VPWR net146 sky130_fd_sc_hd__dlygate4sd3_1
Xhold87 fifo2.mem\[9\]\[7\] VGND VGND VPWR VPWR net135 sky130_fd_sc_hd__dlygate4sd3_1
XFILLER_0_53_203 VPWR VGND VPWR VGND sky130_ef_sc_hd__decap_12
XFILLER_0_19_491 VPWR VGND VPWR VGND sky130_ef_sc_hd__decap_12
XFILLER_0_53_225 VPWR VGND VPWR VGND sky130_ef_sc_hd__decap_12
XFILLER_0_1_517 VPWR VGND VPWR VGND sky130_ef_sc_hd__decap_12
XANTENNA_7 _1729_ VGND VGND VPWR VPWR sky130_fd_sc_hd__diode_2
XTAP_306 VGND VPWR sky130_fd_sc_hd__tapvpwrvgnd_1
XFILLER_0_67_27 VGND VGND VPWR VPWR sky130_fd_sc_hd__decap_4
XTAP_339 VGND VPWR sky130_fd_sc_hd__tapvpwrvgnd_1
XTAP_328 VGND VPWR sky130_fd_sc_hd__tapvpwrvgnd_1
XTAP_317 VGND VPWR sky130_fd_sc_hd__tapvpwrvgnd_1
X_2120_ _0628_ _0714_ _0721_ VGND VGND VPWR VPWR _1090_ sky130_fd_sc_hd__and3_2
XFILLER_0_16_20 VGND VGND VPWR VPWR sky130_fd_sc_hd__decap_8
XFILLER_0_69_380 VGND VGND VPWR VPWR sky130_fd_sc_hd__fill_1
XFILLER_0_91_309 VPWR VGND VPWR VGND sky130_ef_sc_hd__decap_12
X_2953_ _1654_ _1648_ VGND VGND VPWR VPWR _1657_ sky130_fd_sc_hd__nand2_1
X_2884_ fifo2.count\[0\] _1508_ VGND VGND VPWR VPWR _1590_ sky130_fd_sc_hd__or2_1
XFILLER_0_32_85 VGND VGND VPWR VPWR sky130_fd_sc_hd__fill_1
X_4623_ clknet_leaf_32_clock _0429_ VGND VGND VPWR VPWR fifo2.rd_pointer\[2\] sky130_fd_sc_hd__dfxtp_2
X_4554_ clknet_leaf_26_clock _0360_ VGND VGND VPWR VPWR fifo2.mem\[2\]\[1\] sky130_fd_sc_hd__dfxtp_1
XFILLER_0_12_111 VGND VGND VPWR VPWR sky130_fd_sc_hd__decap_3
XFILLER_0_4_377 VPWR VGND VPWR VGND sky130_ef_sc_hd__decap_12
X_3505_ _0767_ _0746_ _0871_ _2081_ net119 VGND VGND VPWR VPWR _0568_ sky130_fd_sc_hd__a32o_1
XFILLER_0_40_475 VGND VGND VPWR VPWR sky130_fd_sc_hd__fill_1
X_4485_ clknet_leaf_36_clock _0291_ VGND VGND VPWR VPWR fifo2.mem\[13\]\[4\] sky130_fd_sc_hd__dfxtp_1
X_3436_ fifo3.count\[2\] _2039_ _0790_ VGND VGND VPWR VPWR _2040_ sky130_fd_sc_hd__o21ai_1
X_3367_ _1406_ _0874_ _1407_ VGND VGND VPWR VPWR _1985_ sky130_fd_sc_hd__and3_1
XTAP_840 VGND VPWR sky130_fd_sc_hd__tapvpwrvgnd_1
XTAP_851 VGND VPWR sky130_fd_sc_hd__tapvpwrvgnd_1
XTAP_862 VGND VPWR sky130_fd_sc_hd__tapvpwrvgnd_1
XTAP_895 VGND VPWR sky130_fd_sc_hd__tapvpwrvgnd_1
XTAP_884 VGND VPWR sky130_fd_sc_hd__tapvpwrvgnd_1
XTAP_873 VGND VPWR sky130_fd_sc_hd__tapvpwrvgnd_1
X_2318_ _1188_ fifo1.mem\[6\]\[2\] _1177_ VGND VGND VPWR VPWR _1206_ sky130_fd_sc_hd__o21a_1
X_3298_ fifo3.mem\[3\]\[5\] _1804_ VGND VGND VPWR VPWR _1925_ sky130_fd_sc_hd__and2b_1
X_2249_ _0748_ _1122_ fifo1.wr_pointer\[1\] VGND VGND VPWR VPWR _1146_ sky130_fd_sc_hd__a21o_1
XFILLER_0_67_306 VGND VGND VPWR VPWR sky130_fd_sc_hd__decap_8
XFILLER_0_82_309 VPWR VGND VPWR VGND sky130_ef_sc_hd__decap_12
XFILLER_0_75_361 VGND VGND VPWR VPWR sky130_fd_sc_hd__decap_6
XFILLER_0_35_214 VGND VGND VPWR VPWR sky130_fd_sc_hd__fill_2
XFILLER_0_35_225 VGND VGND VPWR VPWR sky130_fd_sc_hd__decap_4
XFILLER_0_31_420 VGND VGND VPWR VPWR sky130_fd_sc_hd__decap_3
Xoutput33 net33 VGND VGND VPWR VPWR data_out_2[2] sky130_fd_sc_hd__clkbuf_4
Xoutput22 net22 VGND VGND VPWR VPWR data_out_0[7] sky130_fd_sc_hd__clkbuf_4
XFILLER_0_9_3 VPWR VGND VPWR VGND sky130_ef_sc_hd__decap_12
XFILLER_0_58_317 VGND VGND VPWR VPWR sky130_fd_sc_hd__fill_1
XFILLER_0_85_169 VGND VGND VPWR VPWR sky130_fd_sc_hd__fill_1
XPHY_161 VGND VGND VPWR VPWR sky130_fd_sc_hd__decap_3
XPHY_150 VGND VGND VPWR VPWR sky130_fd_sc_hd__decap_3
XPHY_183 VGND VGND VPWR VPWR sky130_fd_sc_hd__decap_3
XPHY_172 VGND VGND VPWR VPWR sky130_fd_sc_hd__decap_3
XFILLER_0_66_383 VGND VGND VPWR VPWR sky130_fd_sc_hd__decap_3
X_4270_ clknet_leaf_26_clock _0084_ VGND VGND VPWR VPWR syn.count1\[1\] sky130_fd_sc_hd__dfxtp_1
X_3221_ fifo3.mem\[1\]\[2\] _1804_ VGND VGND VPWR VPWR _1851_ sky130_fd_sc_hd__and2b_1
X_3152_ _0734_ _1152_ _1153_ net57 VGND VGND VPWR VPWR _0498_ sky130_fd_sc_hd__a22o_1
XFILLER_0_27_52 VGND VGND VPWR VPWR sky130_fd_sc_hd__decap_4
X_3083_ _0759_ _0838_ _1758_ _1762_ VGND VGND VPWR VPWR _0466_ sky130_fd_sc_hd__a31o_1
XFILLER_0_76_114 VGND VGND VPWR VPWR sky130_fd_sc_hd__decap_8
XFILLER_0_76_158 VGND VGND VPWR VPWR sky130_fd_sc_hd__decap_8
XFILLER_0_43_51 VGND VGND VPWR VPWR sky130_fd_sc_hd__decap_4
XFILLER_0_9_447 VGND VGND VPWR VPWR sky130_fd_sc_hd__fill_1
X_3985_ _0731_ VGND VGND VPWR VPWR _0926_ sky130_fd_sc_hd__buf_4
XFILLER_0_64_309 VGND VGND VPWR VPWR sky130_fd_sc_hd__decap_4
XFILLER_0_17_225 VPWR VGND VPWR VGND sky130_ef_sc_hd__decap_12
X_2936_ _1550_ fifo2.mem\[8\]\[4\] _1558_ VGND VGND VPWR VPWR _1640_ sky130_fd_sc_hd__o21bai_1
X_2867_ fifo2.mem\[1\]\[2\] _1572_ VGND VGND VPWR VPWR _1573_ sky130_fd_sc_hd__nor2_1
XFILLER_0_87_3 VPWR VGND VPWR VGND sky130_ef_sc_hd__decap_12
X_4606_ clknet_leaf_13_clock _0412_ VGND VGND VPWR VPWR fifo1.mem\[1\]\[8\] sky130_fd_sc_hd__dfxtp_1
XFILLER_0_72_397 VGND VGND VPWR VPWR sky130_fd_sc_hd__fill_2
XFILLER_0_4_141 VGND VGND VPWR VPWR sky130_fd_sc_hd__fill_2
XFILLER_0_13_442 VGND VGND VPWR VPWR sky130_fd_sc_hd__decap_6
X_2798_ fifo2.rd_pointer\[3\] _1513_ _0983_ VGND VGND VPWR VPWR _1514_ sky130_fd_sc_hd__o21ai_1
XFILLER_0_7_51 VGND VGND VPWR VPWR sky130_fd_sc_hd__decap_4
X_4537_ clknet_leaf_19_clock _0343_ VGND VGND VPWR VPWR fifo1.mem\[12\]\[2\] sky130_fd_sc_hd__dfxtp_1
X_4468_ clknet_leaf_4_clock _0274_ VGND VGND VPWR VPWR fifo3.mem\[3\]\[5\] sky130_fd_sc_hd__dfxtp_1
X_3419_ _1814_ _2018_ _2024_ VGND VGND VPWR VPWR _2025_ sky130_fd_sc_hd__o21ai_4
X_4399_ clknet_leaf_8_clock _0213_ VGND VGND VPWR VPWR fifo1.mem\[8\]\[1\] sky130_fd_sc_hd__dfxtp_1
XTAP_670 VGND VPWR sky130_fd_sc_hd__tapvpwrvgnd_1
XTAP_681 VGND VPWR sky130_fd_sc_hd__tapvpwrvgnd_1
XTAP_692 VGND VPWR sky130_fd_sc_hd__tapvpwrvgnd_1
XFILLER_0_84_80 VGND VGND VPWR VPWR sky130_fd_sc_hd__decap_4
XFILLER_0_67_103 VGND VGND VPWR VPWR sky130_fd_sc_hd__fill_1
XFILLER_0_67_169 VGND VGND VPWR VPWR sky130_fd_sc_hd__decap_3
XFILLER_0_16_291 VGND VGND VPWR VPWR sky130_fd_sc_hd__decap_4
XFILLER_0_31_261 VPWR VGND VPWR VGND sky130_ef_sc_hd__decap_12
XFILLER_0_80_27 VGND VGND VPWR VPWR sky130_fd_sc_hd__fill_1
XFILLER_0_86_489 VPWR VGND VPWR VGND sky130_ef_sc_hd__decap_12
XFILLER_0_46_309 VGND VGND VPWR VPWR sky130_fd_sc_hd__fill_1
XFILLER_0_6_417 VGND VGND VPWR VPWR sky130_fd_sc_hd__decap_3
X_3770_ _0635_ _0636_ _0638_ _0639_ VGND VGND VPWR VPWR _0773_ sky130_fd_sc_hd__nand4_4
X_2721_ net262 _1481_ _1483_ _0936_ VGND VGND VPWR VPWR _0383_ sky130_fd_sc_hd__a22o_1
XFILLER_0_54_353 VGND VGND VPWR VPWR sky130_fd_sc_hd__decap_8
XFILLER_0_42_526 VGND VGND VPWR VPWR sky130_fd_sc_hd__decap_6
XFILLER_0_89_69 VPWR VGND VPWR VGND sky130_ef_sc_hd__decap_12
XFILLER_0_81_194 VPWR VGND VPWR VGND sky130_ef_sc_hd__decap_12
X_2652_ _1447_ _1448_ _1450_ _1451_ fifo2.mem\[7\]\[7\] VGND VGND VPWR VPWR _1459_
+ sky130_fd_sc_hd__o311a_1
X_2583_ _0745_ _0955_ _1433_ _1432_ net81 VGND VGND VPWR VPWR _0295_ sky130_fd_sc_hd__a32o_1
X_4322_ clknet_leaf_34_clock _0136_ VGND VGND VPWR VPWR fifo2.mem\[0\]\[4\] sky130_fd_sc_hd__dfxtp_1
X_4253_ clknet_leaf_4_clock _0067_ VGND VGND VPWR VPWR fifo3.mem\[1\]\[5\] sky130_fd_sc_hd__dfxtp_1
X_3204_ _0008_ VGND VGND VPWR VPWR _1834_ sky130_fd_sc_hd__inv_2
X_4184_ regis.packet_parity\[1\] _0682_ _1035_ _1062_ VGND VGND VPWR VPWR _0168_ sky130_fd_sc_hd__o211a_1
X_3135_ fifo3.mem\[4\]\[4\] _0842_ _1788_ VGND VGND VPWR VPWR _1794_ sky130_fd_sc_hd__a21bo_1
X_3066_ _1755_ VGND VGND VPWR VPWR _1756_ sky130_fd_sc_hd__clkbuf_4
XFILLER_0_89_261 VGND VGND VPWR VPWR sky130_fd_sc_hd__decap_8
XFILLER_0_49_103 VGND VGND VPWR VPWR sky130_fd_sc_hd__decap_8
XFILLER_0_9_211 VGND VGND VPWR VPWR sky130_fd_sc_hd__decap_3
XFILLER_0_49_169 VGND VGND VPWR VPWR sky130_fd_sc_hd__decap_3
XFILLER_0_18_512 VPWR VGND VPWR VGND sky130_ef_sc_hd__decap_12
X_3968_ _0914_ VGND VGND VPWR VPWR _0100_ sky130_fd_sc_hd__clkbuf_1
XFILLER_0_57_180 VGND VGND VPWR VPWR sky130_fd_sc_hd__fill_1
XFILLER_0_64_139 VGND VGND VPWR VPWR sky130_fd_sc_hd__fill_1
XFILLER_0_70_71 VGND VGND VPWR VPWR sky130_fd_sc_hd__decap_3
X_2919_ _0006_ VGND VGND VPWR VPWR _1623_ sky130_fd_sc_hd__buf_2
XFILLER_0_70_82 VGND VGND VPWR VPWR sky130_fd_sc_hd__fill_2
X_3899_ _0855_ _0867_ net327 _0857_ _0868_ VGND VGND VPWR VPWR _0077_ sky130_fd_sc_hd__a32o_1
Xclkbuf_leaf_17_clock clknet_3_3__leaf_clock VGND VGND VPWR VPWR clknet_leaf_17_clock
+ sky130_fd_sc_hd__clkbuf_16
XFILLER_0_5_494 VGND VGND VPWR VPWR sky130_fd_sc_hd__decap_8
Xhold151 fifo1.mem\[10\]\[4\] VGND VGND VPWR VPWR net199 sky130_fd_sc_hd__dlygate4sd3_1
Xhold162 fifo2.mem\[5\]\[7\] VGND VGND VPWR VPWR net210 sky130_fd_sc_hd__dlygate4sd3_1
Xhold140 fifo2.mem\[3\]\[5\] VGND VGND VPWR VPWR net188 sky130_fd_sc_hd__dlygate4sd3_1
Xhold184 fifo1.mem\[1\]\[4\] VGND VGND VPWR VPWR net232 sky130_fd_sc_hd__dlygate4sd3_1
Xhold173 fifo3.mem\[10\]\[5\] VGND VGND VPWR VPWR net221 sky130_fd_sc_hd__dlygate4sd3_1
Xhold195 fifo1.mem\[5\]\[7\] VGND VGND VPWR VPWR net243 sky130_fd_sc_hd__dlygate4sd3_1
XFILLER_0_28_309 VGND VGND VPWR VPWR sky130_fd_sc_hd__fill_1
XFILLER_0_68_489 VGND VGND VPWR VPWR sky130_fd_sc_hd__fill_2
XFILLER_0_91_15 VPWR VGND VPWR VGND sky130_ef_sc_hd__decap_12
XFILLER_0_59_401 VPWR VGND VPWR VGND sky130_ef_sc_hd__decap_12
XFILLER_0_86_253 VPWR VGND VPWR VGND sky130_ef_sc_hd__decap_12
X_3822_ _0812_ VGND VGND VPWR VPWR _0056_ sky130_fd_sc_hd__clkbuf_1
XFILLER_0_24_97 VGND VGND VPWR VPWR sky130_fd_sc_hd__fill_1
XFILLER_0_82_470 VGND VGND VPWR VPWR sky130_fd_sc_hd__decap_6
XFILLER_0_27_386 VGND VGND VPWR VPWR sky130_fd_sc_hd__decap_6
XFILLER_0_40_41 VPWR VGND VPWR VGND sky130_ef_sc_hd__decap_12
XFILLER_0_54_172 VPWR VGND VPWR VGND sky130_ef_sc_hd__decap_12
X_3753_ _0761_ _0755_ _0758_ net170 VGND VGND VPWR VPWR _0038_ sky130_fd_sc_hd__a22o_1
X_3684_ syn.count0\[0\] syn.count0\[1\] syn.count0\[3\] syn.count0\[2\] syn.count0\[4\]
+ VGND VGND VPWR VPWR _0707_ sky130_fd_sc_hd__a41o_1
X_2704_ fifo2.mem\[5\]\[1\] _1478_ _1480_ _0926_ VGND VGND VPWR VPWR _0369_ sky130_fd_sc_hd__a22o_1
XFILLER_0_30_507 VPWR VGND VPWR VGND sky130_ef_sc_hd__decap_12
X_2635_ _0717_ _0619_ VGND VGND VPWR VPWR _1449_ sky130_fd_sc_hd__nand2_1
XFILLER_0_10_253 VGND VGND VPWR VPWR sky130_fd_sc_hd__decap_3
X_4305_ clknet_leaf_0_clock _0119_ VGND VGND VPWR VPWR fifo3.mem\[6\]\[5\] sky130_fd_sc_hd__dfxtp_1
X_2566_ _0736_ _1425_ _1429_ _1430_ net104 VGND VGND VPWR VPWR _0281_ sky130_fd_sc_hd__a32o_1
X_2497_ _1176_ fifo1.mem\[12\]\[7\] _1233_ VGND VGND VPWR VPWR _1380_ sky130_fd_sc_hd__o21ba_1
XFILLER_0_10_286 VGND VGND VPWR VPWR sky130_fd_sc_hd__fill_1
XFILLER_0_4_41 VPWR VGND VPWR VGND sky130_ef_sc_hd__decap_12
X_4236_ clknet_leaf_0_clock _0050_ VGND VGND VPWR VPWR fifo3.mem\[7\]\[6\] sky130_fd_sc_hd__dfxtp_1
X_4167_ _1050_ regis.internal_parity\[4\] _1042_ VGND VGND VPWR VPWR _1051_ sky130_fd_sc_hd__a21boi_1
X_3118_ _0934_ _1771_ _1784_ VGND VGND VPWR VPWR _0479_ sky130_fd_sc_hd__a21o_1
X_4098_ regis.fifo_full_state\[2\] _0990_ _0690_ VGND VGND VPWR VPWR _1001_ sky130_fd_sc_hd__o21ba_1
XFILLER_0_77_231 VPWR VGND VPWR VGND sky130_ef_sc_hd__decap_12
X_3049_ _0958_ _1467_ _1449_ _0719_ VGND VGND VPWR VPWR _1748_ sky130_fd_sc_hd__o31a_1
XFILLER_0_80_407 VPWR VGND VPWR VGND sky130_ef_sc_hd__decap_12
XFILLER_0_45_194 VPWR VGND VPWR VGND sky130_ef_sc_hd__decap_12
XFILLER_0_60_131 VGND VGND VPWR VPWR sky130_fd_sc_hd__fill_2
XFILLER_0_71_429 VGND VGND VPWR VPWR sky130_fd_sc_hd__decap_6
XFILLER_0_12_529 VGND VGND VPWR VPWR sky130_fd_sc_hd__decap_3
XFILLER_0_3_239 VGND VGND VPWR VPWR sky130_fd_sc_hd__decap_3
X_2420_ _1303_ _1295_ _1304_ VGND VGND VPWR VPWR _1305_ sky130_fd_sc_hd__a21oi_1
XFILLER_0_10_77 VGND VGND VPWR VPWR sky130_fd_sc_hd__fill_1
XFILLER_0_86_15 VPWR VGND VPWR VGND sky130_ef_sc_hd__decap_12
XFILLER_0_86_59 VGND VGND VPWR VPWR sky130_fd_sc_hd__fill_2
X_2351_ _1234_ _1235_ _1236_ _1237_ VGND VGND VPWR VPWR _1238_ sky130_fd_sc_hd__o22ai_2
X_2282_ _1171_ VGND VGND VPWR VPWR _0256_ sky130_fd_sc_hd__clkbuf_1
X_4021_ _0932_ _0943_ _0949_ VGND VGND VPWR VPWR _0118_ sky130_fd_sc_hd__o21a_1
XFILLER_0_79_529 VPWR VGND VPWR VGND sky130_ef_sc_hd__decap_12
XFILLER_0_35_74 VGND VGND VPWR VPWR sky130_fd_sc_hd__fill_1
XFILLER_0_74_201 VGND VGND VPWR VPWR sky130_fd_sc_hd__fill_2
XFILLER_0_47_415 VGND VGND VPWR VPWR sky130_fd_sc_hd__decap_4
XFILLER_0_74_245 VGND VGND VPWR VPWR sky130_fd_sc_hd__decap_6
XFILLER_0_7_501 VGND VGND VPWR VPWR sky130_fd_sc_hd__decap_3
X_4785_ clknet_leaf_49_clock _0591_ VGND VGND VPWR VPWR fifo3.mem\[12\]\[4\] sky130_fd_sc_hd__dfxtp_1
X_3805_ _0779_ VGND VGND VPWR VPWR _0799_ sky130_fd_sc_hd__clkbuf_4
XFILLER_0_55_481 VGND VGND VPWR VPWR sky130_fd_sc_hd__decap_8
X_3736_ fifo1.wr_pointer\[0\] VGND VGND VPWR VPWR _0748_ sky130_fd_sc_hd__buf_2
XFILLER_0_70_473 VGND VGND VPWR VPWR sky130_fd_sc_hd__decap_3
X_3667_ _0695_ VGND VGND VPWR VPWR _0013_ sky130_fd_sc_hd__clkbuf_1
XFILLER_0_42_197 VGND VGND VPWR VPWR sky130_fd_sc_hd__decap_6
X_3598_ fifo3.rd_pointer\[3\] fifo3.wr_pointer\[3\] VGND VGND VPWR VPWR _0636_ sky130_fd_sc_hd__or2b_1
X_2618_ _0767_ _0870_ _1431_ _1441_ net96 VGND VGND VPWR VPWR _0322_ sky130_fd_sc_hd__a32o_1
X_2549_ _0738_ _1416_ _0837_ _1418_ net224 VGND VGND VPWR VPWR _0273_ sky130_fd_sc_hd__a32o_1
X_4219_ clknet_leaf_27_clock _0033_ VGND VGND VPWR VPWR fifo2.mem\[3\]\[7\] sky130_fd_sc_hd__dfxtp_1
XFILLER_0_21_337 VPWR VGND VPWR VGND sky130_ef_sc_hd__decap_12
XFILLER_0_88_304 VGND VGND VPWR VPWR sky130_fd_sc_hd__decap_4
XFILLER_0_8_309 VGND VGND VPWR VPWR sky130_fd_sc_hd__decap_4
XFILLER_0_71_237 VGND VGND VPWR VPWR sky130_fd_sc_hd__decap_6
XFILLER_0_37_481 VGND VGND VPWR VPWR sky130_fd_sc_hd__decap_4
X_4570_ clknet_leaf_21_clock _0376_ VGND VGND VPWR VPWR fifo2.mem\[5\]\[8\] sky130_fd_sc_hd__dfxtp_1
X_3521_ _1760_ _0840_ _1773_ fifo3.mem\[10\]\[7\] _1783_ VGND VGND VPWR VPWR _2091_
+ sky130_fd_sc_hd__o311a_1
X_3452_ _2032_ _2046_ _2053_ VGND VGND VPWR VPWR _2054_ sky130_fd_sc_hd__o21ai_1
X_3383_ fifo2.mem\[4\]\[1\] fifo2.mem\[5\]\[1\] fifo2.mem\[6\]\[1\] fifo2.mem\[7\]\[1\]
+ _1669_ _1702_ VGND VGND VPWR VPWR _1996_ sky130_fd_sc_hd__mux4_1
X_2403_ _1283_ _1285_ _1288_ VGND VGND VPWR VPWR _1289_ sky130_fd_sc_hd__o21ai_1
X_2334_ _1221_ fifo1.mem\[8\]\[2\] _1177_ VGND VGND VPWR VPWR _1222_ sky130_fd_sc_hd__o21ba_1
X_2265_ _1156_ _1157_ VGND VGND VPWR VPWR _1158_ sky130_fd_sc_hd__nand2_1
X_4004_ net123 _0922_ _0924_ _0938_ VGND VGND VPWR VPWR _0112_ sky130_fd_sc_hd__a22o_1
X_2196_ _1120_ VGND VGND VPWR VPWR _1121_ sky130_fd_sc_hd__clkbuf_4
XFILLER_0_79_337 VPWR VGND VPWR VGND sky130_ef_sc_hd__decap_12
XFILLER_0_90_513 VPWR VGND VPWR VGND sky130_ef_sc_hd__decap_12
XFILLER_0_62_237 VPWR VGND VPWR VGND sky130_ef_sc_hd__decap_12
XFILLER_0_15_131 VGND VGND VPWR VPWR sky130_fd_sc_hd__decap_8
X_4768_ clknet_leaf_56_clock _0574_ VGND VGND VPWR VPWR fifo3.mem\[10\]\[5\] sky130_fd_sc_hd__dfxtp_1
X_4699_ clknet_leaf_15_clock _0505_ VGND VGND VPWR VPWR fifo1.mem\[14\]\[0\] sky130_fd_sc_hd__dfxtp_1
XFILLER_0_15_164 VGND VGND VPWR VPWR sky130_fd_sc_hd__decap_4
X_3719_ _0736_ _0715_ _0724_ _0730_ net74 VGND VGND VPWR VPWR _0029_ sky130_fd_sc_hd__a32o_1
XFILLER_0_30_189 VGND VGND VPWR VPWR sky130_fd_sc_hd__decap_6
Xhold22 fifo2.mem\[0\]\[7\] VGND VGND VPWR VPWR net70 sky130_fd_sc_hd__dlygate4sd3_1
Xhold11 fifo3.mem\[13\]\[1\] VGND VGND VPWR VPWR net59 sky130_fd_sc_hd__dlygate4sd3_1
Xhold55 fifo3.mem\[14\]\[4\] VGND VGND VPWR VPWR net103 sky130_fd_sc_hd__dlygate4sd3_1
Xhold44 fifo3.mem\[1\]\[6\] VGND VGND VPWR VPWR net92 sky130_fd_sc_hd__dlygate4sd3_1
Xhold33 fifo2.mem\[13\]\[8\] VGND VGND VPWR VPWR net81 sky130_fd_sc_hd__dlygate4sd3_1
Xhold77 fifo2.mem\[1\]\[1\] VGND VGND VPWR VPWR net125 sky130_fd_sc_hd__dlygate4sd3_1
Xhold66 fifo2.mem\[3\]\[0\] VGND VGND VPWR VPWR net114 sky130_fd_sc_hd__dlygate4sd3_1
Xhold99 fifo3.mem\[14\]\[6\] VGND VGND VPWR VPWR net147 sky130_fd_sc_hd__dlygate4sd3_1
Xhold88 fifo1.mem\[4\]\[2\] VGND VGND VPWR VPWR net136 sky130_fd_sc_hd__dlygate4sd3_1
XFILLER_0_53_237 VPWR VGND VPWR VGND sky130_ef_sc_hd__decap_12
XANTENNA_8 _1916_ VGND VGND VPWR VPWR sky130_fd_sc_hd__diode_2
XFILLER_0_61_281 VGND VGND VPWR VPWR sky130_fd_sc_hd__decap_6
XFILLER_0_1_529 VPWR VGND VPWR VGND sky130_ef_sc_hd__decap_12
XTAP_329 VGND VPWR sky130_fd_sc_hd__tapvpwrvgnd_1
XTAP_318 VGND VPWR sky130_fd_sc_hd__tapvpwrvgnd_1
XTAP_307 VGND VPWR sky130_fd_sc_hd__tapvpwrvgnd_1
XFILLER_0_76_307 VGND VGND VPWR VPWR sky130_fd_sc_hd__fill_1
XFILLER_0_16_98 VGND VGND VPWR VPWR sky130_fd_sc_hd__decap_8
XFILLER_0_84_340 VPWR VGND VPWR VGND sky130_ef_sc_hd__decap_12
X_2952_ _1629_ _1632_ _1655_ VGND VGND VPWR VPWR _1656_ sky130_fd_sc_hd__o21bai_1
X_2883_ fifo2.count\[0\] _1508_ _1553_ VGND VGND VPWR VPWR _1589_ sky130_fd_sc_hd__a21oi_1
X_4622_ clknet_leaf_32_clock _0428_ VGND VGND VPWR VPWR fifo2.rd_pointer\[1\] sky130_fd_sc_hd__dfxtp_1
X_4553_ clknet_leaf_27_clock _0359_ VGND VGND VPWR VPWR fifo2.mem\[2\]\[0\] sky130_fd_sc_hd__dfxtp_1
XFILLER_0_40_421 VGND VGND VPWR VPWR sky130_fd_sc_hd__fill_1
XFILLER_0_52_270 VGND VGND VPWR VPWR sky130_fd_sc_hd__fill_1
XFILLER_0_4_389 VPWR VGND VPWR VGND sky130_ef_sc_hd__decap_12
X_3504_ _0765_ _0746_ _0871_ _2081_ net75 VGND VGND VPWR VPWR _0567_ sky130_fd_sc_hd__a32o_1
X_4484_ clknet_leaf_37_clock _0290_ VGND VGND VPWR VPWR fifo2.mem\[13\]\[3\] sky130_fd_sc_hd__dfxtp_1
XFILLER_0_12_156 VGND VGND VPWR VPWR sky130_fd_sc_hd__decap_4
X_3435_ _2025_ _2020_ VGND VGND VPWR VPWR _2039_ sky130_fd_sc_hd__nand2_1
X_3366_ _0637_ _1404_ _1405_ VGND VGND VPWR VPWR _0527_ sky130_fd_sc_hd__a21oi_1
XTAP_830 VGND VPWR sky130_fd_sc_hd__tapvpwrvgnd_1
XTAP_841 VGND VPWR sky130_fd_sc_hd__tapvpwrvgnd_1
XTAP_852 VGND VPWR sky130_fd_sc_hd__tapvpwrvgnd_1
XTAP_885 VGND VPWR sky130_fd_sc_hd__tapvpwrvgnd_1
XTAP_874 VGND VPWR sky130_fd_sc_hd__tapvpwrvgnd_1
X_3297_ _1849_ fifo3.mem\[2\]\[5\] _1806_ VGND VGND VPWR VPWR _1924_ sky130_fd_sc_hd__o21ai_1
X_2317_ _1203_ fifo1.mem\[5\]\[2\] _1204_ VGND VGND VPWR VPWR _1205_ sky130_fd_sc_hd__o21ai_1
XTAP_863 VGND VPWR sky130_fd_sc_hd__tapvpwrvgnd_1
XTAP_896 VGND VPWR sky130_fd_sc_hd__tapvpwrvgnd_1
XFILLER_0_32_3 VPWR VGND VPWR VGND sky130_ef_sc_hd__decap_12
X_2248_ _0748_ _1122_ _1145_ VGND VGND VPWR VPWR _0248_ sky130_fd_sc_hd__o21a_1
X_2179_ _1108_ _1114_ _1115_ net230 VGND VGND VPWR VPWR _0209_ sky130_fd_sc_hd__a22o_1
XFILLER_0_79_189 VGND VGND VPWR VPWR sky130_fd_sc_hd__fill_1
XFILLER_0_79_178 VGND VGND VPWR VPWR sky130_fd_sc_hd__fill_1
XFILLER_0_63_502 VGND VGND VPWR VPWR sky130_fd_sc_hd__fill_2
XFILLER_0_63_513 VGND VGND VPWR VPWR sky130_fd_sc_hd__fill_2
XFILLER_0_90_321 VPWR VGND VPWR VGND sky130_ef_sc_hd__decap_12
XFILLER_0_90_365 VPWR VGND VPWR VGND sky130_ef_sc_hd__decap_12
XFILLER_0_31_443 VGND VGND VPWR VPWR sky130_fd_sc_hd__decap_4
Xoutput23 net23 VGND VGND VPWR VPWR data_out_1[0] sky130_fd_sc_hd__clkbuf_4
Xoutput34 net34 VGND VGND VPWR VPWR data_out_2[3] sky130_fd_sc_hd__buf_2
XFILLER_0_31_498 VGND VGND VPWR VPWR sky130_fd_sc_hd__decap_6
XFILLER_0_58_307 VGND VGND VPWR VPWR sky130_fd_sc_hd__fill_1
XPHY_151 VGND VGND VPWR VPWR sky130_fd_sc_hd__decap_3
XFILLER_0_54_513 VGND VGND VPWR VPWR sky130_fd_sc_hd__decap_3
XPHY_140 VGND VGND VPWR VPWR sky130_fd_sc_hd__decap_3
XPHY_173 VGND VGND VPWR VPWR sky130_fd_sc_hd__decap_3
XFILLER_0_81_310 VGND VGND VPWR VPWR sky130_fd_sc_hd__fill_1
XPHY_162 VGND VGND VPWR VPWR sky130_fd_sc_hd__decap_3
XFILLER_0_26_215 VGND VGND VPWR VPWR sky130_fd_sc_hd__fill_1
XFILLER_0_26_226 VGND VGND VPWR VPWR sky130_fd_sc_hd__fill_1
XFILLER_0_1_337 VPWR VGND VPWR VGND sky130_ef_sc_hd__decap_12
X_3220_ fifo3.mem\[0\]\[2\] _1849_ _1841_ VGND VGND VPWR VPWR _1850_ sky130_fd_sc_hd__o21bai_1
X_3151_ _0732_ _1152_ _1153_ net284 VGND VGND VPWR VPWR _0497_ sky130_fd_sc_hd__a22o_1
X_3082_ _1760_ _1419_ _0835_ _0782_ fifo3.mem\[2\]\[1\] VGND VGND VPWR VPWR _1762_
+ sky130_fd_sc_hd__o311a_1
X_3984_ net185 _0922_ _0924_ _0925_ VGND VGND VPWR VPWR _0105_ sky130_fd_sc_hd__a22o_1
XFILLER_0_9_437 VGND VGND VPWR VPWR sky130_fd_sc_hd__fill_1
XFILLER_0_17_237 VGND VGND VPWR VPWR sky130_fd_sc_hd__decap_4
X_2935_ fifo2.mem\[11\]\[4\] _1556_ VGND VGND VPWR VPWR _1639_ sky130_fd_sc_hd__and2b_1
XFILLER_0_72_365 VPWR VGND VPWR VGND sky130_ef_sc_hd__decap_12
XFILLER_0_72_354 VGND VGND VPWR VPWR sky130_fd_sc_hd__fill_1
X_2866_ _0004_ VGND VGND VPWR VPWR _1572_ sky130_fd_sc_hd__inv_2
X_4605_ clknet_leaf_13_clock _0411_ VGND VGND VPWR VPWR fifo1.mem\[1\]\[7\] sky130_fd_sc_hd__dfxtp_1
Xhold300 fifo2.mem\[10\]\[7\] VGND VGND VPWR VPWR net348 sky130_fd_sc_hd__dlygate4sd3_1
X_2797_ fifo2.rd_pointer\[2\] fifo2.rd_pointer\[1\] fifo2.rd_pointer\[0\] _1504_ VGND
+ VGND VPWR VPWR _1513_ sky130_fd_sc_hd__and4_1
X_4536_ clknet_leaf_16_clock _0342_ VGND VGND VPWR VPWR fifo1.mem\[12\]\[1\] sky130_fd_sc_hd__dfxtp_1
XFILLER_0_13_476 VGND VGND VPWR VPWR sky130_fd_sc_hd__fill_2
XFILLER_0_4_197 VGND VGND VPWR VPWR sky130_fd_sc_hd__decap_6
X_4467_ clknet_leaf_3_clock _0273_ VGND VGND VPWR VPWR fifo3.mem\[3\]\[4\] sky130_fd_sc_hd__dfxtp_1
X_3418_ _2009_ _2011_ VGND VGND VPWR VPWR _2024_ sky130_fd_sc_hd__nand2_1
X_4398_ clknet_leaf_8_clock _0212_ VGND VGND VPWR VPWR fifo1.mem\[8\]\[0\] sky130_fd_sc_hd__dfxtp_1
X_3349_ _1971_ _1973_ _1809_ VGND VGND VPWR VPWR _1974_ sky130_fd_sc_hd__a21oi_1
XTAP_660 VGND VPWR sky130_fd_sc_hd__tapvpwrvgnd_1
XTAP_671 VGND VPWR sky130_fd_sc_hd__tapvpwrvgnd_1
XTAP_682 VGND VPWR sky130_fd_sc_hd__tapvpwrvgnd_1
XTAP_693 VGND VPWR sky130_fd_sc_hd__tapvpwrvgnd_1
XFILLER_0_48_373 VGND VGND VPWR VPWR sky130_fd_sc_hd__fill_2
XFILLER_0_51_527 VPWR VGND VPWR VGND sky130_ef_sc_hd__decap_12
XFILLER_0_90_195 VGND VGND VPWR VPWR sky130_fd_sc_hd__fill_1
XFILLER_0_16_281 VGND VGND VPWR VPWR sky130_fd_sc_hd__decap_4
XFILLER_0_31_273 VGND VGND VPWR VPWR sky130_fd_sc_hd__decap_6
XFILLER_0_80_17 VGND VGND VPWR VPWR sky130_fd_sc_hd__fill_2
XFILLER_0_89_15 VPWR VGND VPWR VGND sky130_ef_sc_hd__decap_12
X_2720_ net248 _1481_ _1483_ _0934_ VGND VGND VPWR VPWR _0382_ sky130_fd_sc_hd__a22o_1
XFILLER_0_54_365 VGND VGND VPWR VPWR sky130_fd_sc_hd__fill_2
X_2651_ _0764_ _0856_ _1446_ _1458_ VGND VGND VPWR VPWR _0338_ sky130_fd_sc_hd__a31o_1
XFILLER_0_22_251 VGND VGND VPWR VPWR sky130_fd_sc_hd__fill_1
X_2582_ _0744_ _0955_ _1433_ _1432_ net63 VGND VGND VPWR VPWR _0294_ sky130_fd_sc_hd__a32o_1
XFILLER_0_1_167 VGND VGND VPWR VPWR sky130_fd_sc_hd__fill_1
X_4321_ clknet_leaf_33_clock _0135_ VGND VGND VPWR VPWR fifo2.mem\[0\]\[3\] sky130_fd_sc_hd__dfxtp_1
X_4252_ clknet_leaf_2_clock _0066_ VGND VGND VPWR VPWR fifo3.mem\[1\]\[4\] sky130_fd_sc_hd__dfxtp_1
X_3203_ _1832_ fifo3.mem\[8\]\[2\] VGND VGND VPWR VPWR _1833_ sky130_fd_sc_hd__nor2_1
X_4183_ _0658_ _0680_ _0681_ VGND VGND VPWR VPWR _1062_ sky130_fd_sc_hd__or3b_1
XFILLER_0_38_85 VGND VGND VPWR VPWR sky130_fd_sc_hd__decap_6
X_3134_ _0930_ _1789_ _1793_ VGND VGND VPWR VPWR _0486_ sky130_fd_sc_hd__o21a_1
Xclkbuf_0_clock clock VGND VGND VPWR VPWR clknet_0_clock sky130_fd_sc_hd__clkbuf_16
X_3065_ _0831_ _0823_ fifo3.wr_pointer\[2\] VGND VGND VPWR VPWR _1755_ sky130_fd_sc_hd__and3b_1
XFILLER_0_89_273 VGND VGND VPWR VPWR sky130_fd_sc_hd__fill_2
XFILLER_0_18_524 VGND VGND VPWR VPWR sky130_fd_sc_hd__decap_8
X_3967_ net4 regis.fifo_full_state\[3\] _0910_ VGND VGND VPWR VPWR _0914_ sky130_fd_sc_hd__mux2_1
X_2918_ _1619_ _1620_ _1621_ VGND VGND VPWR VPWR _1622_ sky130_fd_sc_hd__and3_1
XFILLER_0_9_278 VGND VGND VPWR VPWR sky130_fd_sc_hd__fill_2
XFILLER_0_45_354 VPWR VGND VPWR VGND sky130_ef_sc_hd__decap_12
XFILLER_0_33_505 VPWR VGND VPWR VGND sky130_ef_sc_hd__decap_12
X_3898_ _0725_ _0858_ _0742_ _0860_ VGND VGND VPWR VPWR _0868_ sky130_fd_sc_hd__and4b_1
XFILLER_0_72_195 VGND VGND VPWR VPWR sky130_fd_sc_hd__fill_1
X_2849_ fifo2.mem\[5\]\[2\] VGND VGND VPWR VPWR _1555_ sky130_fd_sc_hd__inv_2
XFILLER_0_60_379 VPWR VGND VPWR VGND sky130_ef_sc_hd__decap_12
Xhold141 fifo1.mem\[15\]\[8\] VGND VGND VPWR VPWR net189 sky130_fd_sc_hd__dlygate4sd3_1
Xhold152 fifo2.mem\[13\]\[2\] VGND VGND VPWR VPWR net200 sky130_fd_sc_hd__dlygate4sd3_1
Xhold130 fifo1.mem\[8\]\[0\] VGND VGND VPWR VPWR net178 sky130_fd_sc_hd__dlygate4sd3_1
X_4519_ clknet_leaf_22_clock _0325_ VGND VGND VPWR VPWR fifo2.mem\[4\]\[2\] sky130_fd_sc_hd__dfxtp_1
Xhold185 fifo3.mem\[11\]\[4\] VGND VGND VPWR VPWR net233 sky130_fd_sc_hd__dlygate4sd3_1
Xhold174 fifo3.mem\[13\]\[2\] VGND VGND VPWR VPWR net222 sky130_fd_sc_hd__dlygate4sd3_1
Xhold163 fifo1.mem\[5\]\[8\] VGND VGND VPWR VPWR net211 sky130_fd_sc_hd__dlygate4sd3_1
Xhold196 fifo2.mem\[4\]\[1\] VGND VGND VPWR VPWR net244 sky130_fd_sc_hd__dlygate4sd3_1
XTAP_490 VGND VPWR sky130_fd_sc_hd__tapvpwrvgnd_1
XFILLER_0_68_413 VGND VGND VPWR VPWR sky130_fd_sc_hd__decap_6
XFILLER_0_83_405 VGND VGND VPWR VPWR sky130_fd_sc_hd__decap_3
XFILLER_0_83_449 VPWR VGND VPWR VGND sky130_ef_sc_hd__decap_12
XFILLER_0_36_321 VPWR VGND VPWR VGND sky130_ef_sc_hd__decap_12
XFILLER_0_91_27 VGND VGND VPWR VPWR sky130_fd_sc_hd__fill_1
XFILLER_0_59_413 VGND VGND VPWR VPWR sky130_fd_sc_hd__fill_2
XFILLER_0_24_21 VGND VGND VPWR VPWR sky130_fd_sc_hd__decap_6
XFILLER_0_86_265 VPWR VGND VPWR VGND sky130_ef_sc_hd__decap_12
XFILLER_0_74_405 VGND VGND VPWR VPWR sky130_fd_sc_hd__fill_1
X_3821_ _0811_ _0735_ _0805_ VGND VGND VPWR VPWR _0812_ sky130_fd_sc_hd__mux2_1
XFILLER_0_46_129 VGND VGND VPWR VPWR sky130_fd_sc_hd__decap_8
XFILLER_0_27_332 VGND VGND VPWR VPWR sky130_fd_sc_hd__decap_4
XFILLER_0_27_343 VGND VGND VPWR VPWR sky130_fd_sc_hd__fill_1
XFILLER_0_39_192 VGND VGND VPWR VPWR sky130_fd_sc_hd__decap_3
XFILLER_0_15_505 VPWR VGND VPWR VGND sky130_ef_sc_hd__decap_12
XFILLER_0_40_53 VPWR VGND VPWR VGND sky130_ef_sc_hd__decap_12
X_3752_ _0735_ VGND VGND VPWR VPWR _0761_ sky130_fd_sc_hd__buf_4
X_3683_ _0706_ VGND VGND VPWR VPWR _0023_ sky130_fd_sc_hd__clkbuf_1
XFILLER_0_54_184 VGND VGND VPWR VPWR sky130_fd_sc_hd__fill_2
XFILLER_0_54_195 VGND VGND VPWR VPWR sky130_fd_sc_hd__fill_1
X_2703_ fifo2.mem\[5\]\[0\] _1478_ _1480_ _0925_ VGND VGND VPWR VPWR _0368_ sky130_fd_sc_hd__a22o_1
XFILLER_0_2_421 VPWR VGND VPWR VGND sky130_ef_sc_hd__decap_12
XFILLER_0_30_519 VPWR VGND VPWR VGND sky130_ef_sc_hd__decap_12
X_2634_ _0958_ VGND VGND VPWR VPWR _1448_ sky130_fd_sc_hd__buf_2
X_2565_ _0734_ _1425_ _1429_ _1430_ net213 VGND VGND VPWR VPWR _0280_ sky130_fd_sc_hd__a32o_1
X_4304_ clknet_leaf_0_clock _0118_ VGND VGND VPWR VPWR fifo3.mem\[6\]\[4\] sky130_fd_sc_hd__dfxtp_1
X_2496_ _1375_ _1376_ _1378_ VGND VGND VPWR VPWR _1379_ sky130_fd_sc_hd__o21a_1
X_4235_ clknet_leaf_0_clock _0049_ VGND VGND VPWR VPWR fifo3.mem\[7\]\[5\] sky130_fd_sc_hd__dfxtp_1
X_4166_ regis.header_byte\[4\] _0993_ _1040_ net5 VGND VGND VPWR VPWR _1050_ sky130_fd_sc_hd__a22o_1
XFILLER_0_4_53 VPWR VGND VPWR VGND sky130_ef_sc_hd__decap_12
XFILLER_0_65_50 VGND VGND VPWR VPWR sky130_fd_sc_hd__decap_6
X_3117_ _0839_ _1779_ _1781_ fifo3.mem\[9\]\[5\] _1783_ VGND VGND VPWR VPWR _1784_
+ sky130_fd_sc_hd__o311a_1
X_4097_ _0998_ _1000_ _0996_ VGND VGND VPWR VPWR _0143_ sky130_fd_sc_hd__a21boi_1
X_3048_ _0974_ _1747_ VGND VGND VPWR VPWR _0446_ sky130_fd_sc_hd__nor2_1
XFILLER_0_77_243 VPWR VGND VPWR VGND sky130_ef_sc_hd__decap_12
XFILLER_0_65_405 VGND VGND VPWR VPWR sky130_fd_sc_hd__decap_8
XFILLER_0_65_449 VPWR VGND VPWR VGND sky130_ef_sc_hd__decap_12
XFILLER_0_80_419 VGND VGND VPWR VPWR sky130_fd_sc_hd__fill_1
XFILLER_0_18_365 VGND VGND VPWR VPWR sky130_fd_sc_hd__fill_2
XFILLER_0_33_324 VGND VGND VPWR VPWR sky130_fd_sc_hd__decap_6
XFILLER_0_5_281 VGND VGND VPWR VPWR sky130_fd_sc_hd__fill_1
XFILLER_0_33_357 VGND VGND VPWR VPWR sky130_fd_sc_hd__decap_6
XFILLER_0_3_207 VGND VGND VPWR VPWR sky130_fd_sc_hd__fill_1
XFILLER_0_24_379 VGND VGND VPWR VPWR sky130_fd_sc_hd__fill_2
XFILLER_0_86_27 VGND VGND VPWR VPWR sky130_fd_sc_hd__fill_1
XFILLER_0_19_21 VGND VGND VPWR VPWR sky130_fd_sc_hd__fill_1
X_2350_ fifo1.mem\[5\]\[3\] _1221_ VGND VGND VPWR VPWR _1237_ sky130_fd_sc_hd__and2b_1
X_2281_ _1168_ _1169_ _1170_ VGND VGND VPWR VPWR _1171_ sky130_fd_sc_hd__and3b_1
X_4020_ fifo3.mem\[6\]\[4\] _0944_ _0942_ VGND VGND VPWR VPWR _0949_ sky130_fd_sc_hd__a21bo_1
Xclkbuf_leaf_16_clock clknet_3_3__leaf_clock VGND VGND VPWR VPWR clknet_leaf_16_clock
+ sky130_fd_sc_hd__clkbuf_16
XFILLER_0_59_210 VGND VGND VPWR VPWR sky130_fd_sc_hd__fill_1
X_4784_ clknet_leaf_49_clock _0590_ VGND VGND VPWR VPWR fifo3.mem\[12\]\[3\] sky130_fd_sc_hd__dfxtp_1
X_3804_ _0797_ _0778_ _0790_ _0798_ VGND VGND VPWR VPWR _0052_ sky130_fd_sc_hd__a31o_1
X_3735_ _0712_ VGND VGND VPWR VPWR _0747_ sky130_fd_sc_hd__clkbuf_8
XFILLER_0_42_121 VGND VGND VPWR VPWR sky130_fd_sc_hd__fill_1
X_3666_ _0650_ _0651_ _0694_ fsm1.present_state\[1\] VGND VGND VPWR VPWR _0695_ sky130_fd_sc_hd__and4_1
XFILLER_0_70_485 VPWR VGND VPWR VGND sky130_ef_sc_hd__decap_12
X_3597_ _0634_ fifo3.rd_pointer\[3\] VGND VGND VPWR VPWR _0635_ sky130_fd_sc_hd__nand2_1
X_2617_ _0765_ _0870_ _1431_ _1441_ net135 VGND VGND VPWR VPWR _0321_ sky130_fd_sc_hd__a32o_1
XFILLER_0_62_3 VGND VGND VPWR VPWR sky130_fd_sc_hd__fill_1
X_2548_ _0736_ _1416_ _0837_ _1418_ net306 VGND VGND VPWR VPWR _0272_ sky130_fd_sc_hd__a32o_1
X_4218_ clknet_leaf_28_clock _0032_ VGND VGND VPWR VPWR fifo2.mem\[3\]\[6\] sky130_fd_sc_hd__dfxtp_1
X_2479_ fifo1.mem\[7\]\[5\] _1320_ _1361_ VGND VGND VPWR VPWR _1362_ sky130_fd_sc_hd__o21ai_1
X_4149_ net8 _1027_ _1035_ _1038_ VGND VGND VPWR VPWR _0157_ sky130_fd_sc_hd__o211a_1
XFILLER_0_21_316 VGND VGND VPWR VPWR sky130_fd_sc_hd__decap_8
XFILLER_0_84_533 VGND VGND VPWR VPWR sky130_fd_sc_hd__decap_8
XFILLER_0_29_449 VGND VGND VPWR VPWR sky130_fd_sc_hd__decap_6
XFILLER_0_71_205 VGND VGND VPWR VPWR sky130_fd_sc_hd__fill_2
XFILLER_0_44_419 VGND VGND VPWR VPWR sky130_fd_sc_hd__fill_1
XFILLER_0_21_33 VGND VGND VPWR VPWR sky130_fd_sc_hd__fill_1
X_3520_ _0936_ _2084_ _2090_ VGND VGND VPWR VPWR _0575_ sky130_fd_sc_hd__a21o_1
XFILLER_0_52_452 VGND VGND VPWR VPWR sky130_fd_sc_hd__fill_1
XFILLER_0_52_474 VGND VGND VPWR VPWR sky130_fd_sc_hd__fill_2
X_3451_ _1947_ _1953_ _1964_ VGND VGND VPWR VPWR _2053_ sky130_fd_sc_hd__o21ai_1
X_2402_ _1286_ _1259_ _1287_ _1194_ VGND VGND VPWR VPWR _1288_ sky130_fd_sc_hd__a31o_1
X_3382_ _1625_ _1991_ _0996_ _1995_ VGND VGND VPWR VPWR _0532_ sky130_fd_sc_hd__o211a_1
X_2333_ _0000_ VGND VGND VPWR VPWR _1221_ sky130_fd_sc_hd__clkbuf_4
X_2264_ fifo1.count\[5\] fifo1.count\[4\] fifo1.count\[3\] VGND VGND VPWR VPWR _1157_
+ sky130_fd_sc_hd__nor3_1
X_4003_ _0765_ VGND VGND VPWR VPWR _0938_ sky130_fd_sc_hd__buf_4
X_2195_ _1119_ VGND VGND VPWR VPWR _1120_ sky130_fd_sc_hd__clkbuf_4
XFILLER_0_46_96 VGND VGND VPWR VPWR sky130_fd_sc_hd__decap_4
XFILLER_0_47_279 VGND VGND VPWR VPWR sky130_fd_sc_hd__fill_1
XFILLER_0_90_525 VGND VGND VPWR VPWR sky130_fd_sc_hd__decap_6
XFILLER_0_62_249 VGND VGND VPWR VPWR sky130_fd_sc_hd__decap_3
X_4767_ clknet_leaf_60_clock _0573_ VGND VGND VPWR VPWR fifo3.mem\[10\]\[4\] sky130_fd_sc_hd__dfxtp_1
X_4698_ clknet_leaf_17_clock _0504_ VGND VGND VPWR VPWR fifo1.mem\[15\]\[8\] sky130_fd_sc_hd__dfxtp_1
X_3718_ _0735_ VGND VGND VPWR VPWR _0736_ sky130_fd_sc_hd__buf_4
X_3649_ _0679_ _0682_ _0654_ VGND VGND VPWR VPWR _0683_ sky130_fd_sc_hd__and3_1
XFILLER_0_11_360 VGND VGND VPWR VPWR sky130_fd_sc_hd__fill_1
Xhold23 fifo3.mem\[13\]\[8\] VGND VGND VPWR VPWR net71 sky130_fd_sc_hd__dlygate4sd3_1
Xhold12 fifo2.mem\[9\]\[1\] VGND VGND VPWR VPWR net60 sky130_fd_sc_hd__dlygate4sd3_1
Xhold34 fifo2.mem\[1\]\[6\] VGND VGND VPWR VPWR net82 sky130_fd_sc_hd__dlygate4sd3_1
Xhold45 fifo3.mem\[11\]\[3\] VGND VGND VPWR VPWR net93 sky130_fd_sc_hd__dlygate4sd3_1
Xhold56 fifo2.mem\[14\]\[3\] VGND VGND VPWR VPWR net104 sky130_fd_sc_hd__dlygate4sd3_1
Xhold78 fifo1.mem\[13\]\[6\] VGND VGND VPWR VPWR net126 sky130_fd_sc_hd__dlygate4sd3_1
Xhold67 fifo1.mem\[4\]\[4\] VGND VGND VPWR VPWR net115 sky130_fd_sc_hd__dlygate4sd3_1
Xhold89 fifo1.mem\[10\]\[2\] VGND VGND VPWR VPWR net137 sky130_fd_sc_hd__dlygate4sd3_1
XFILLER_0_38_235 VGND VGND VPWR VPWR sky130_fd_sc_hd__fill_1
XFILLER_0_66_533 VGND VGND VPWR VPWR sky130_fd_sc_hd__decap_8
XFILLER_0_26_419 VGND VGND VPWR VPWR sky130_fd_sc_hd__fill_1
XANTENNA_9 _2005_ VGND VGND VPWR VPWR sky130_fd_sc_hd__diode_2
XFILLER_0_21_113 VGND VGND VPWR VPWR sky130_fd_sc_hd__decap_4
XFILLER_0_21_124 VPWR VGND VPWR VGND sky130_ef_sc_hd__decap_12
XFILLER_0_21_179 VGND VGND VPWR VPWR sky130_fd_sc_hd__fill_1
XTAP_319 VGND VPWR sky130_fd_sc_hd__tapvpwrvgnd_1
XTAP_308 VGND VPWR sky130_fd_sc_hd__tapvpwrvgnd_1
X_2951_ _1637_ _1643_ _1625_ _1648_ _1654_ VGND VGND VPWR VPWR _1655_ sky130_fd_sc_hd__a32oi_4
XFILLER_0_84_352 VPWR VGND VPWR VGND sky130_ef_sc_hd__decap_12
X_4621_ clknet_leaf_32_clock _0427_ VGND VGND VPWR VPWR fifo2.rd_pointer\[0\] sky130_fd_sc_hd__dfxtp_2
X_2882_ _1537_ _1565_ _1575_ _1581_ _1587_ VGND VGND VPWR VPWR _1588_ sky130_fd_sc_hd__a32oi_4
X_4552_ clknet_leaf_16_clock _0358_ VGND VGND VPWR VPWR fifo1.mem\[13\]\[8\] sky130_fd_sc_hd__dfxtp_1
X_3503_ _2082_ _0963_ fifo2.mem\[11\]\[6\] _0715_ _0868_ VGND VGND VPWR VPWR _0566_
+ sky130_fd_sc_hd__a32o_1
X_4483_ clknet_leaf_38_clock _0289_ VGND VGND VPWR VPWR fifo2.mem\[13\]\[2\] sky130_fd_sc_hd__dfxtp_1
XFILLER_0_0_530 VGND VGND VPWR VPWR sky130_fd_sc_hd__fill_2
X_3434_ net12 net42 _2036_ _2037_ _2019_ VGND VGND VPWR VPWR _2038_ sky130_fd_sc_hd__a41o_1
X_3365_ _1984_ VGND VGND VPWR VPWR _0526_ sky130_fd_sc_hd__clkbuf_1
XTAP_820 VGND VPWR sky130_fd_sc_hd__tapvpwrvgnd_1
XTAP_831 VGND VPWR sky130_fd_sc_hd__tapvpwrvgnd_1
XTAP_842 VGND VPWR sky130_fd_sc_hd__tapvpwrvgnd_1
XTAP_853 VGND VPWR sky130_fd_sc_hd__tapvpwrvgnd_1
XTAP_886 VGND VPWR sky130_fd_sc_hd__tapvpwrvgnd_1
XTAP_875 VGND VPWR sky130_fd_sc_hd__tapvpwrvgnd_1
X_3296_ _1919_ _1922_ _1809_ VGND VGND VPWR VPWR _1923_ sky130_fd_sc_hd__o21a_1
X_2316_ _1188_ fifo1.mem\[4\]\[2\] _1177_ VGND VGND VPWR VPWR _1204_ sky130_fd_sc_hd__o21ba_1
XTAP_864 VGND VPWR sky130_fd_sc_hd__tapvpwrvgnd_1
XTAP_897 VGND VPWR sky130_fd_sc_hd__tapvpwrvgnd_1
X_2247_ _0748_ _1122_ _0757_ VGND VGND VPWR VPWR _1145_ sky130_fd_sc_hd__a21oi_1
XFILLER_0_25_3 VGND VGND VPWR VPWR sky130_fd_sc_hd__fill_1
X_2178_ _1107_ _1114_ _1115_ net242 VGND VGND VPWR VPWR _0208_ sky130_fd_sc_hd__a22o_1
XFILLER_0_79_146 VPWR VGND VPWR VGND sky130_ef_sc_hd__decap_12
XFILLER_0_48_533 VGND VGND VPWR VPWR sky130_fd_sc_hd__decap_8
XFILLER_0_90_333 VPWR VGND VPWR VGND sky130_ef_sc_hd__decap_12
XFILLER_0_35_238 VGND VGND VPWR VPWR sky130_fd_sc_hd__decap_6
XFILLER_0_90_377 VPWR VGND VPWR VGND sky130_ef_sc_hd__decap_12
XFILLER_0_16_474 VGND VGND VPWR VPWR sky130_fd_sc_hd__fill_2
XFILLER_0_43_293 VGND VGND VPWR VPWR sky130_fd_sc_hd__decap_4
Xoutput24 net24 VGND VGND VPWR VPWR data_out_1[1] sky130_fd_sc_hd__buf_2
XFILLER_0_31_455 VPWR VGND VPWR VGND sky130_ef_sc_hd__decap_12
Xoutput35 net35 VGND VGND VPWR VPWR data_out_2[4] sky130_fd_sc_hd__clkbuf_4
XFILLER_0_11_190 VGND VGND VPWR VPWR sky130_fd_sc_hd__decap_8
XFILLER_0_85_105 VGND VGND VPWR VPWR sky130_fd_sc_hd__decap_6
XPHY_152 VGND VGND VPWR VPWR sky130_fd_sc_hd__decap_3
XPHY_130 VGND VGND VPWR VPWR sky130_fd_sc_hd__decap_3
XFILLER_0_66_363 VGND VGND VPWR VPWR sky130_fd_sc_hd__fill_1
XPHY_141 VGND VGND VPWR VPWR sky130_fd_sc_hd__decap_3
XPHY_174 VGND VGND VPWR VPWR sky130_fd_sc_hd__decap_3
XPHY_163 VGND VGND VPWR VPWR sky130_fd_sc_hd__decap_3
XFILLER_0_81_300 VGND VGND VPWR VPWR sky130_fd_sc_hd__fill_2
XFILLER_0_81_388 VGND VGND VPWR VPWR sky130_fd_sc_hd__decap_4
XFILLER_0_1_349 VPWR VGND VPWR VGND sky130_ef_sc_hd__decap_12
X_3150_ _1110_ _1152_ _1153_ net282 VGND VGND VPWR VPWR _0496_ sky130_fd_sc_hd__a22o_1
X_3081_ _0747_ _0838_ _1758_ _1761_ VGND VGND VPWR VPWR _0465_ sky130_fd_sc_hd__a31o_1
XFILLER_0_9_449 VPWR VGND VPWR VGND sky130_ef_sc_hd__decap_12
X_3983_ _0712_ VGND VGND VPWR VPWR _0925_ sky130_fd_sc_hd__buf_4
X_2934_ _1539_ fifo2.mem\[10\]\[4\] _1562_ VGND VGND VPWR VPWR _1638_ sky130_fd_sc_hd__o21ai_1
XFILLER_0_57_396 VGND VGND VPWR VPWR sky130_fd_sc_hd__fill_1
X_2865_ _1569_ fifo2.mem\[0\]\[2\] _1570_ VGND VGND VPWR VPWR _1571_ sky130_fd_sc_hd__o21bai_1
X_4604_ clknet_leaf_11_clock _0410_ VGND VGND VPWR VPWR fifo1.mem\[1\]\[6\] sky130_fd_sc_hd__dfxtp_1
XFILLER_0_72_377 VPWR VGND VPWR VGND sky130_ef_sc_hd__decap_12
XFILLER_0_60_539 VGND VGND VPWR VPWR sky130_fd_sc_hd__fill_2
X_4535_ clknet_leaf_15_clock _0341_ VGND VGND VPWR VPWR fifo1.mem\[12\]\[0\] sky130_fd_sc_hd__dfxtp_1
X_2796_ fifo2.rd_pointer\[2\] net43 _1512_ VGND VGND VPWR VPWR _0429_ sky130_fd_sc_hd__a21oi_1
X_4466_ clknet_leaf_4_clock _0272_ VGND VGND VPWR VPWR fifo3.mem\[3\]\[3\] sky130_fd_sc_hd__dfxtp_1
X_4397_ clknet_leaf_13_clock _0211_ VGND VGND VPWR VPWR fifo1.mem\[2\]\[8\] sky130_fd_sc_hd__dfxtp_1
X_3417_ _1845_ _1861_ VGND VGND VPWR VPWR _2023_ sky130_fd_sc_hd__nand2_1
XFILLER_0_68_83 VGND VGND VPWR VPWR sky130_fd_sc_hd__fill_1
X_3348_ fifo3.mem\[11\]\[7\] _1942_ _1972_ VGND VGND VPWR VPWR _1973_ sky130_fd_sc_hd__o21ai_1
XFILLER_0_0_393 VPWR VGND VPWR VGND sky130_ef_sc_hd__decap_12
XTAP_650 VGND VPWR sky130_fd_sc_hd__tapvpwrvgnd_1
XTAP_661 VGND VPWR sky130_fd_sc_hd__tapvpwrvgnd_1
XTAP_672 VGND VPWR sky130_fd_sc_hd__tapvpwrvgnd_1
XTAP_683 VGND VPWR sky130_fd_sc_hd__tapvpwrvgnd_1
XTAP_694 VGND VPWR sky130_fd_sc_hd__tapvpwrvgnd_1
X_3279_ _0008_ fifo3.mem\[2\]\[4\] _1841_ VGND VGND VPWR VPWR _1907_ sky130_fd_sc_hd__o21a_1
XFILLER_0_67_149 VPWR VGND VPWR VGND sky130_ef_sc_hd__decap_12
XFILLER_0_48_330 VGND VGND VPWR VPWR sky130_fd_sc_hd__fill_1
XFILLER_0_48_363 VGND VGND VPWR VPWR sky130_fd_sc_hd__fill_1
XFILLER_0_75_160 VGND VGND VPWR VPWR sky130_fd_sc_hd__fill_1
XFILLER_0_90_141 VPWR VGND VPWR VGND sky130_ef_sc_hd__decap_12
XFILLER_0_23_219 VGND VGND VPWR VPWR sky130_fd_sc_hd__fill_2
XFILLER_0_51_539 VGND VGND VPWR VPWR sky130_fd_sc_hd__fill_2
XFILLER_0_86_436 VPWR VGND VPWR VGND sky130_ef_sc_hd__decap_12
XFILLER_0_13_45 VGND VGND VPWR VPWR sky130_fd_sc_hd__decap_4
XFILLER_0_66_160 VGND VGND VPWR VPWR sky130_fd_sc_hd__decap_8
XFILLER_0_81_141 VGND VGND VPWR VPWR sky130_fd_sc_hd__fill_1
XFILLER_0_13_78 VPWR VGND VPWR VGND sky130_ef_sc_hd__decap_12
XFILLER_0_66_193 VGND VGND VPWR VPWR sky130_fd_sc_hd__decap_3
XFILLER_0_89_27 VPWR VGND VPWR VGND sky130_ef_sc_hd__decap_12
X_2650_ _1447_ _1448_ _1450_ _1451_ fifo2.mem\[7\]\[6\] VGND VGND VPWR VPWR _1458_
+ sky130_fd_sc_hd__o311a_1
X_2581_ _0743_ _0955_ _1433_ _1432_ net153 VGND VGND VPWR VPWR _0293_ sky130_fd_sc_hd__a32o_1
X_4320_ clknet_leaf_33_clock _0134_ VGND VGND VPWR VPWR fifo2.mem\[0\]\[2\] sky130_fd_sc_hd__dfxtp_1
X_4251_ clknet_leaf_3_clock _0065_ VGND VGND VPWR VPWR fifo3.mem\[1\]\[3\] sky130_fd_sc_hd__dfxtp_1
X_3202_ _0008_ VGND VGND VPWR VPWR _1832_ sky130_fd_sc_hd__clkbuf_4
X_4182_ _0659_ _1059_ _1035_ _1061_ VGND VGND VPWR VPWR _0167_ sky130_fd_sc_hd__o211a_1
X_3133_ fifo3.mem\[4\]\[3\] _0842_ _1788_ VGND VGND VPWR VPWR _1793_ sky130_fd_sc_hd__a21bo_1
X_3064_ _1753_ VGND VGND VPWR VPWR _1754_ sky130_fd_sc_hd__buf_2
XFILLER_0_9_268 VGND VGND VPWR VPWR sky130_fd_sc_hd__fill_2
X_3966_ _0913_ VGND VGND VPWR VPWR _0099_ sky130_fd_sc_hd__clkbuf_1
X_2917_ fifo2.count\[1\] fifo2.count\[0\] fifo2.count\[2\] VGND VGND VPWR VPWR _1621_
+ sky130_fd_sc_hd__o21ai_1
XFILLER_0_72_130 VGND VGND VPWR VPWR sky130_fd_sc_hd__fill_1
XFILLER_0_72_141 VGND VGND VPWR VPWR sky130_fd_sc_hd__fill_1
XFILLER_0_33_517 VGND VGND VPWR VPWR sky130_fd_sc_hd__decap_6
XFILLER_0_45_366 VGND VGND VPWR VPWR sky130_fd_sc_hd__fill_2
X_3897_ _0729_ VGND VGND VPWR VPWR _0867_ sky130_fd_sc_hd__clkbuf_4
X_2848_ _1553_ VGND VGND VPWR VPWR _1554_ sky130_fd_sc_hd__buf_2
XFILLER_0_33_539 VGND VGND VPWR VPWR sky130_fd_sc_hd__fill_2
XFILLER_0_45_399 VGND VGND VPWR VPWR sky130_fd_sc_hd__fill_2
X_2779_ _1446_ _1499_ _0981_ VGND VGND VPWR VPWR _0425_ sky130_fd_sc_hd__o21a_1
X_4518_ clknet_leaf_23_clock _0324_ VGND VGND VPWR VPWR fifo2.mem\[4\]\[1\] sky130_fd_sc_hd__dfxtp_1
Xhold120 fifo1.mem\[10\]\[1\] VGND VGND VPWR VPWR net168 sky130_fd_sc_hd__dlygate4sd3_1
Xhold153 fifo1.mem\[10\]\[0\] VGND VGND VPWR VPWR net201 sky130_fd_sc_hd__dlygate4sd3_1
Xhold142 fifo1.mem\[4\]\[7\] VGND VGND VPWR VPWR net190 sky130_fd_sc_hd__dlygate4sd3_1
Xhold131 fifo1.mem\[10\]\[3\] VGND VGND VPWR VPWR net179 sky130_fd_sc_hd__dlygate4sd3_1
Xhold186 fifo1.mem\[13\]\[3\] VGND VGND VPWR VPWR net234 sky130_fd_sc_hd__dlygate4sd3_1
Xhold175 fifo3.mem\[12\]\[3\] VGND VGND VPWR VPWR net223 sky130_fd_sc_hd__dlygate4sd3_1
XFILLER_0_0_9 VPWR VGND VPWR VGND sky130_ef_sc_hd__decap_12
Xhold164 fifo2.mem\[9\]\[6\] VGND VGND VPWR VPWR net212 sky130_fd_sc_hd__dlygate4sd3_1
X_4449_ clknet_leaf_20_clock _0255_ VGND VGND VPWR VPWR fifo1.rd_pointer\[2\] sky130_fd_sc_hd__dfxtp_1
Xhold197 fifo1.mem\[8\]\[6\] VGND VGND VPWR VPWR net245 sky130_fd_sc_hd__dlygate4sd3_1
XTAP_480 VGND VPWR sky130_fd_sc_hd__tapvpwrvgnd_1
XTAP_491 VGND VPWR sky130_fd_sc_hd__tapvpwrvgnd_1
XFILLER_0_68_447 VGND VGND VPWR VPWR sky130_fd_sc_hd__decap_4
XFILLER_0_36_333 VPWR VGND VPWR VGND sky130_ef_sc_hd__decap_12
XFILLER_0_91_461 VPWR VGND VPWR VGND sky130_ef_sc_hd__decap_12
XFILLER_0_86_277 VPWR VGND VPWR VGND sky130_ef_sc_hd__decap_12
X_3820_ _0779_ fifo3.mem\[8\]\[3\] _0800_ VGND VGND VPWR VPWR _0811_ sky130_fd_sc_hd__and3_1
X_3751_ _0760_ _0755_ _0758_ net100 VGND VGND VPWR VPWR _0037_ sky130_fd_sc_hd__a22o_1
XFILLER_0_15_517 VPWR VGND VPWR VGND sky130_ef_sc_hd__decap_12
XFILLER_0_27_366 VPWR VGND VPWR VGND sky130_ef_sc_hd__decap_12
XFILLER_0_42_303 VGND VGND VPWR VPWR sky130_fd_sc_hd__decap_4
X_2702_ _1479_ VGND VGND VPWR VPWR _1480_ sky130_fd_sc_hd__buf_2
X_3682_ _0701_ _0704_ _0705_ VGND VGND VPWR VPWR _0706_ sky130_fd_sc_hd__and3b_1
XFILLER_0_40_65 VPWR VGND VPWR VGND sky130_ef_sc_hd__decap_12
X_2633_ _0728_ VGND VGND VPWR VPWR _1447_ sky130_fd_sc_hd__buf_2
XFILLER_0_2_433 VGND VGND VPWR VPWR sky130_fd_sc_hd__fill_1
X_2564_ _0732_ _1426_ _1429_ _1430_ net172 VGND VGND VPWR VPWR _0279_ sky130_fd_sc_hd__a32o_1
XFILLER_0_2_477 VPWR VGND VPWR VGND sky130_ef_sc_hd__decap_12
X_4303_ clknet_leaf_0_clock _0117_ VGND VGND VPWR VPWR fifo3.mem\[6\]\[3\] sky130_fd_sc_hd__dfxtp_1
XFILLER_0_49_52 VGND VGND VPWR VPWR sky130_fd_sc_hd__decap_4
XFILLER_0_64_7 VGND VGND VPWR VPWR sky130_fd_sc_hd__fill_1
X_2495_ _1220_ fifo1.mem\[9\]\[7\] _1377_ VGND VGND VPWR VPWR _1378_ sky130_fd_sc_hd__o21ai_1
X_4234_ clknet_leaf_2_clock _0048_ VGND VGND VPWR VPWR fifo3.mem\[7\]\[4\] sky130_fd_sc_hd__dfxtp_1
X_4165_ regis.internal_parity\[3\] _1048_ _1049_ VGND VGND VPWR VPWR _0162_ sky130_fd_sc_hd__o21a_1
XFILLER_0_4_65 VPWR VGND VPWR VGND sky130_ef_sc_hd__decap_12
X_3116_ _0789_ VGND VGND VPWR VPWR _1783_ sky130_fd_sc_hd__buf_2
X_4096_ regis.header_byte\[1\] _0684_ _0999_ _0989_ VGND VGND VPWR VPWR _1000_ sky130_fd_sc_hd__o2bb2a_1
XFILLER_0_77_222 VGND VGND VPWR VPWR sky130_fd_sc_hd__fill_2
X_3047_ _1553_ _1745_ _1746_ _1713_ VGND VGND VPWR VPWR _1747_ sky130_fd_sc_hd__o22a_1
XFILLER_0_77_277 VGND VGND VPWR VPWR sky130_fd_sc_hd__decap_3
X_3949_ syn.count2\[0\] syn.count2\[1\] syn.count2\[2\] syn.count2\[3\] VGND VGND
+ VPWR VPWR _0903_ sky130_fd_sc_hd__a31o_1
XFILLER_0_45_141 VPWR VGND VPWR VGND sky130_ef_sc_hd__decap_12
XFILLER_0_73_494 VGND VGND VPWR VPWR sky130_fd_sc_hd__decap_8
XFILLER_0_60_166 VGND VGND VPWR VPWR sky130_fd_sc_hd__decap_4
XFILLER_0_41_391 VGND VGND VPWR VPWR sky130_fd_sc_hd__fill_1
XFILLER_0_49_480 VGND VGND VPWR VPWR sky130_fd_sc_hd__decap_8
XFILLER_0_36_141 VPWR VGND VPWR VGND sky130_ef_sc_hd__decap_12
XFILLER_0_24_358 VGND VGND VPWR VPWR sky130_fd_sc_hd__fill_1
XFILLER_0_51_177 VGND VGND VPWR VPWR sky130_fd_sc_hd__decap_4
X_2280_ fifo1.rd_pointer\[2\] fifo1.rd_pointer\[1\] _1155_ _1160_ fifo1.rd_pointer\[3\]
+ VGND VGND VPWR VPWR _1170_ sky130_fd_sc_hd__a41o_1
Xclkbuf_3_2__f_clock clknet_0_clock VGND VGND VPWR VPWR clknet_3_2__leaf_clock sky130_fd_sc_hd__clkbuf_16
XFILLER_0_59_222 VGND VGND VPWR VPWR sky130_fd_sc_hd__fill_2
XFILLER_0_47_439 VGND VGND VPWR VPWR sky130_fd_sc_hd__fill_1
X_3803_ _0785_ _0789_ fifo3.mem\[7\]\[8\] VGND VGND VPWR VPWR _0798_ sky130_fd_sc_hd__and3_1
XFILLER_0_15_303 VGND VGND VPWR VPWR sky130_fd_sc_hd__fill_1
X_4783_ clknet_leaf_47_clock _0589_ VGND VGND VPWR VPWR fifo3.mem\[12\]\[2\] sky130_fd_sc_hd__dfxtp_1
X_3734_ _0745_ _0746_ _0741_ _0730_ net68 VGND VGND VPWR VPWR _0034_ sky130_fd_sc_hd__a32o_1
X_3665_ _0693_ VGND VGND VPWR VPWR _0694_ sky130_fd_sc_hd__buf_4
X_2616_ _0743_ _0870_ _1431_ _1441_ net212 VGND VGND VPWR VPWR _0320_ sky130_fd_sc_hd__a32o_1
XFILLER_0_70_497 VPWR VGND VPWR VGND sky130_ef_sc_hd__decap_12
X_3596_ fifo3.wr_pointer\[3\] VGND VGND VPWR VPWR _0634_ sky130_fd_sc_hd__inv_2
X_2547_ _0734_ _1416_ _0837_ _1418_ net52 VGND VGND VPWR VPWR _0271_ sky130_fd_sc_hd__a32o_1
XFILLER_0_55_3 VPWR VGND VPWR VGND sky130_ef_sc_hd__decap_12
X_2478_ _1295_ fifo1.mem\[6\]\[5\] _1183_ VGND VGND VPWR VPWR _1361_ sky130_fd_sc_hd__o21a_1
X_4217_ clknet_leaf_28_clock _0031_ VGND VGND VPWR VPWR fifo2.mem\[3\]\[5\] sky130_fd_sc_hd__dfxtp_1
X_4148_ _1026_ _0680_ _0656_ regis.header_byte\[7\] VGND VGND VPWR VPWR _1038_ sky130_fd_sc_hd__a31o_1
XFILLER_0_78_531 VGND VGND VPWR VPWR sky130_fd_sc_hd__fill_1
X_4079_ _0984_ VGND VGND VPWR VPWR _0141_ sky130_fd_sc_hd__clkbuf_1
XFILLER_0_65_203 VGND VGND VPWR VPWR sky130_fd_sc_hd__fill_1
XFILLER_0_65_214 VGND VGND VPWR VPWR sky130_fd_sc_hd__fill_1
XFILLER_0_18_141 VPWR VGND VPWR VGND sky130_ef_sc_hd__decap_12
XFILLER_0_65_269 VGND VGND VPWR VPWR sky130_fd_sc_hd__decap_4
XFILLER_0_61_420 VGND VGND VPWR VPWR sky130_fd_sc_hd__decap_8
XFILLER_0_33_166 VGND VGND VPWR VPWR sky130_fd_sc_hd__fill_2
XFILLER_0_69_531 VGND VGND VPWR VPWR sky130_fd_sc_hd__decap_8
XFILLER_0_84_501 VPWR VGND VPWR VGND sky130_ef_sc_hd__decap_12
XFILLER_0_21_78 VGND VGND VPWR VPWR sky130_fd_sc_hd__decap_3
X_3450_ _2050_ _2051_ _2019_ VGND VGND VPWR VPWR _2052_ sky130_fd_sc_hd__a21o_1
X_2401_ fifo1.count\[1\] fifo1.count\[0\] fifo1.count\[2\] VGND VGND VPWR VPWR _1287_
+ sky130_fd_sc_hd__o21ai_1
XFILLER_0_20_361 VGND VGND VPWR VPWR sky130_fd_sc_hd__decap_3
X_3381_ _1547_ _1992_ _1994_ VGND VGND VPWR VPWR _1995_ sky130_fd_sc_hd__a21o_1
X_2332_ _1203_ VGND VGND VPWR VPWR _1220_ sky130_fd_sc_hd__clkbuf_4
X_2263_ fifo1.count\[6\] fifo1.count\[2\] fifo1.count\[1\] fifo1.count\[0\] VGND VGND
+ VPWR VPWR _1156_ sky130_fd_sc_hd__nor4_1
X_4002_ _0936_ _0924_ _0937_ VGND VGND VPWR VPWR _0111_ sky130_fd_sc_hd__a21o_1
X_2194_ _0751_ VGND VGND VPWR VPWR _1119_ sky130_fd_sc_hd__clkbuf_2
XFILLER_0_1_55 VGND VGND VPWR VPWR sky130_fd_sc_hd__fill_1
XFILLER_0_87_361 VPWR VGND VPWR VGND sky130_ef_sc_hd__decap_12
XFILLER_0_1_77 VGND VGND VPWR VPWR sky130_fd_sc_hd__decap_3
XFILLER_0_62_52 VGND VGND VPWR VPWR sky130_fd_sc_hd__fill_2
X_4766_ clknet_leaf_60_clock _0572_ VGND VGND VPWR VPWR fifo3.mem\[10\]\[3\] sky130_fd_sc_hd__dfxtp_1
X_3717_ fifo1.data_in\[3\] VGND VGND VPWR VPWR _0735_ sky130_fd_sc_hd__buf_4
X_4697_ clknet_leaf_17_clock _0503_ VGND VGND VPWR VPWR fifo1.mem\[15\]\[7\] sky130_fd_sc_hd__dfxtp_1
XFILLER_0_70_250 VGND VGND VPWR VPWR sky130_fd_sc_hd__fill_2
X_3648_ _0680_ _0681_ VGND VGND VPWR VPWR _0682_ sky130_fd_sc_hd__nor2b_2
XFILLER_0_43_497 VGND VGND VPWR VPWR sky130_fd_sc_hd__decap_6
XFILLER_0_30_169 VGND VGND VPWR VPWR sky130_fd_sc_hd__decap_4
X_3579_ _0617_ VGND VGND VPWR VPWR net40 sky130_fd_sc_hd__buf_4
Xhold13 fifo1.mem\[1\]\[7\] VGND VGND VPWR VPWR net61 sky130_fd_sc_hd__dlygate4sd3_1
Xhold46 fifo2.mem\[1\]\[0\] VGND VGND VPWR VPWR net94 sky130_fd_sc_hd__dlygate4sd3_1
Xhold24 fifo1.mem\[1\]\[0\] VGND VGND VPWR VPWR net72 sky130_fd_sc_hd__dlygate4sd3_1
Xhold35 fifo3.mem\[13\]\[6\] VGND VGND VPWR VPWR net83 sky130_fd_sc_hd__dlygate4sd3_1
Xclkbuf_leaf_62_clock clknet_3_0__leaf_clock VGND VGND VPWR VPWR clknet_leaf_62_clock
+ sky130_fd_sc_hd__clkbuf_16
Xhold79 fifo1.mem\[2\]\[0\] VGND VGND VPWR VPWR net127 sky130_fd_sc_hd__dlygate4sd3_1
Xhold57 fifo2.mem\[12\]\[3\] VGND VGND VPWR VPWR net105 sky130_fd_sc_hd__dlygate4sd3_1
Xhold68 fifo1.mem\[5\]\[4\] VGND VGND VPWR VPWR net116 sky130_fd_sc_hd__dlygate4sd3_1
XFILLER_0_78_361 VGND VGND VPWR VPWR sky130_fd_sc_hd__decap_3
XFILLER_0_19_461 VPWR VGND VPWR VGND sky130_ef_sc_hd__decap_12
XFILLER_0_34_475 VGND VGND VPWR VPWR sky130_fd_sc_hd__fill_1
Xclkbuf_leaf_15_clock clknet_3_3__leaf_clock VGND VGND VPWR VPWR clknet_leaf_15_clock
+ sky130_fd_sc_hd__clkbuf_16
XFILLER_0_21_136 VGND VGND VPWR VPWR sky130_fd_sc_hd__decap_4
XFILLER_0_21_169 VGND VGND VPWR VPWR sky130_fd_sc_hd__decap_4
XTAP_309 VGND VPWR sky130_fd_sc_hd__tapvpwrvgnd_1
XFILLER_0_88_158 VGND VGND VPWR VPWR sky130_fd_sc_hd__decap_6
XFILLER_0_16_45 VGND VGND VPWR VPWR sky130_fd_sc_hd__decap_4
XFILLER_0_76_309 VGND VGND VPWR VPWR sky130_fd_sc_hd__fill_2
XFILLER_0_69_361 VGND VGND VPWR VPWR sky130_fd_sc_hd__decap_4
XFILLER_0_69_372 VGND VGND VPWR VPWR sky130_fd_sc_hd__fill_1
XFILLER_0_29_236 VPWR VGND VPWR VGND sky130_ef_sc_hd__decap_12
X_2950_ _1653_ _1542_ _0007_ VGND VGND VPWR VPWR _1654_ sky130_fd_sc_hd__a21oi_2
XTAP_1070 VGND VPWR sky130_fd_sc_hd__tapvpwrvgnd_1
X_2881_ _1584_ _1586_ _0006_ VGND VGND VPWR VPWR _1587_ sky130_fd_sc_hd__a21o_1
X_4620_ clknet_leaf_21_clock _0426_ VGND VGND VPWR VPWR fifo2.wr_pointer\[4\] sky130_fd_sc_hd__dfxtp_2
X_4551_ clknet_leaf_16_clock _0357_ VGND VGND VPWR VPWR fifo1.mem\[13\]\[7\] sky130_fd_sc_hd__dfxtp_1
X_4482_ clknet_leaf_38_clock _0288_ VGND VGND VPWR VPWR fifo2.mem\[13\]\[1\] sky130_fd_sc_hd__dfxtp_1
X_3502_ _0739_ _0746_ _0871_ _2081_ net279 VGND VGND VPWR VPWR _0565_ sky130_fd_sc_hd__a32o_1
X_3433_ fifo3.count\[1\] fifo3.count\[0\] fifo3.count\[2\] VGND VGND VPWR VPWR _2037_
+ sky130_fd_sc_hd__o21ai_1
XTAP_810 VGND VPWR sky130_fd_sc_hd__tapvpwrvgnd_1
X_3364_ _1483_ _1481_ fifo3.wr_pointer\[4\] VGND VGND VPWR VPWR _1984_ sky130_fd_sc_hd__mux2_1
XFILLER_0_57_52 VGND VGND VPWR VPWR sky130_fd_sc_hd__decap_4
XTAP_821 VGND VPWR sky130_fd_sc_hd__tapvpwrvgnd_1
XTAP_832 VGND VPWR sky130_fd_sc_hd__tapvpwrvgnd_1
XTAP_843 VGND VPWR sky130_fd_sc_hd__tapvpwrvgnd_1
XTAP_876 VGND VPWR sky130_fd_sc_hd__tapvpwrvgnd_1
X_3295_ _1920_ _1805_ _1921_ VGND VGND VPWR VPWR _1922_ sky130_fd_sc_hd__a21oi_2
X_2315_ _0000_ VGND VGND VPWR VPWR _1203_ sky130_fd_sc_hd__inv_2
XTAP_854 VGND VPWR sky130_fd_sc_hd__tapvpwrvgnd_1
XTAP_865 VGND VPWR sky130_fd_sc_hd__tapvpwrvgnd_1
X_2246_ _0768_ _1141_ _1144_ net287 VGND VGND VPWR VPWR _0247_ sky130_fd_sc_hd__a22o_1
XTAP_898 VGND VPWR sky130_fd_sc_hd__tapvpwrvgnd_1
XTAP_887 VGND VPWR sky130_fd_sc_hd__tapvpwrvgnd_1
XFILLER_0_79_158 VGND VGND VPWR VPWR sky130_fd_sc_hd__decap_3
XFILLER_0_73_73 VGND VGND VPWR VPWR sky130_fd_sc_hd__fill_2
X_2177_ _1106_ _1114_ _1115_ net218 VGND VGND VPWR VPWR _0207_ sky130_fd_sc_hd__a22o_1
XFILLER_0_18_3 VPWR VGND VPWR VGND sky130_ef_sc_hd__decap_12
XFILLER_0_79_169 VGND VGND VPWR VPWR sky130_fd_sc_hd__fill_1
XFILLER_0_48_501 VPWR VGND VPWR VGND sky130_ef_sc_hd__decap_12
XFILLER_0_90_301 VGND VGND VPWR VPWR sky130_fd_sc_hd__decap_6
XFILLER_0_90_345 VPWR VGND VPWR VGND sky130_ef_sc_hd__decap_12
XFILLER_0_90_389 VPWR VGND VPWR VGND sky130_ef_sc_hd__decap_12
X_4749_ clknet_leaf_4_clock _0555_ VGND VGND VPWR VPWR fifo3.mem\[0\]\[4\] sky130_fd_sc_hd__dfxtp_1
Xoutput14 net14 VGND VGND VPWR VPWR busy sky130_fd_sc_hd__clkbuf_4
Xoutput25 net25 VGND VGND VPWR VPWR data_out_1[2] sky130_fd_sc_hd__buf_2
XFILLER_0_31_467 VGND VGND VPWR VPWR sky130_fd_sc_hd__decap_4
Xoutput36 net36 VGND VGND VPWR VPWR data_out_2[5] sky130_fd_sc_hd__clkbuf_4
XFILLER_0_3_391 VGND VGND VPWR VPWR sky130_fd_sc_hd__fill_1
XFILLER_0_58_309 VGND VGND VPWR VPWR sky130_fd_sc_hd__decap_8
XPHY_120 VGND VGND VPWR VPWR sky130_fd_sc_hd__decap_3
XPHY_131 VGND VGND VPWR VPWR sky130_fd_sc_hd__decap_3
XPHY_142 VGND VGND VPWR VPWR sky130_fd_sc_hd__decap_3
XPHY_175 VGND VGND VPWR VPWR sky130_fd_sc_hd__decap_3
XPHY_164 VGND VGND VPWR VPWR sky130_fd_sc_hd__decap_3
XPHY_153 VGND VGND VPWR VPWR sky130_fd_sc_hd__decap_3
XFILLER_0_22_445 VGND VGND VPWR VPWR sky130_fd_sc_hd__fill_1
X_3080_ _1760_ _1419_ _0835_ _0844_ fifo3.mem\[2\]\[0\] VGND VGND VPWR VPWR _1761_
+ sky130_fd_sc_hd__o311a_1
XFILLER_0_89_401 VGND VGND VPWR VPWR sky130_fd_sc_hd__fill_2
XFILLER_0_89_478 VPWR VGND VPWR VGND sky130_ef_sc_hd__decap_12
XFILLER_0_76_128 VGND VGND VPWR VPWR sky130_fd_sc_hd__decap_3
XPHY_0 VGND VGND VPWR VPWR sky130_fd_sc_hd__decap_3
X_3982_ _0923_ VGND VGND VPWR VPWR _0924_ sky130_fd_sc_hd__buf_2
X_2933_ _1634_ _1636_ _1544_ VGND VGND VPWR VPWR _1637_ sky130_fd_sc_hd__a21o_1
X_2864_ _0005_ VGND VGND VPWR VPWR _1570_ sky130_fd_sc_hd__clkbuf_4
X_4603_ clknet_leaf_14_clock _0409_ VGND VGND VPWR VPWR fifo1.mem\[1\]\[5\] sky130_fd_sc_hd__dfxtp_1
XFILLER_0_72_389 VGND VGND VPWR VPWR sky130_fd_sc_hd__decap_8
XFILLER_0_25_261 VGND VGND VPWR VPWR sky130_fd_sc_hd__fill_2
X_2795_ fifo2.rd_pointer\[2\] net44 _0983_ VGND VGND VPWR VPWR _1512_ sky130_fd_sc_hd__o21ai_1
X_4534_ clknet_leaf_23_clock _0340_ VGND VGND VPWR VPWR fifo2.mem\[7\]\[8\] sky130_fd_sc_hd__dfxtp_1
XFILLER_0_13_456 VPWR VGND VPWR VGND sky130_ef_sc_hd__decap_12
XFILLER_0_40_253 VGND VGND VPWR VPWR sky130_fd_sc_hd__decap_6
X_4465_ clknet_leaf_54_clock _0271_ VGND VGND VPWR VPWR fifo3.mem\[3\]\[2\] sky130_fd_sc_hd__dfxtp_1
X_4396_ clknet_leaf_13_clock _0210_ VGND VGND VPWR VPWR fifo1.mem\[2\]\[7\] sky130_fd_sc_hd__dfxtp_1
X_3416_ fifo3.count\[0\] _2020_ VGND VGND VPWR VPWR _2022_ sky130_fd_sc_hd__nor2_1
X_3347_ _1832_ fifo3.mem\[10\]\[7\] _1893_ VGND VGND VPWR VPWR _1972_ sky130_fd_sc_hd__o21a_1
XTAP_640 VGND VPWR sky130_fd_sc_hd__tapvpwrvgnd_1
XTAP_651 VGND VPWR sky130_fd_sc_hd__tapvpwrvgnd_1
XTAP_662 VGND VPWR sky130_fd_sc_hd__tapvpwrvgnd_1
XTAP_673 VGND VPWR sky130_fd_sc_hd__tapvpwrvgnd_1
XTAP_684 VGND VPWR sky130_fd_sc_hd__tapvpwrvgnd_1
XTAP_695 VGND VPWR sky130_fd_sc_hd__tapvpwrvgnd_1
XFILLER_0_84_72 VGND VGND VPWR VPWR sky130_fd_sc_hd__fill_1
X_3278_ _1849_ fifo3.mem\[0\]\[4\] _1857_ VGND VGND VPWR VPWR _1906_ sky130_fd_sc_hd__o21bai_1
X_2229_ fifo1.mem\[6\]\[5\] _1137_ _1139_ _0934_ VGND VGND VPWR VPWR _0235_ sky130_fd_sc_hd__a22o_1
XFILLER_0_90_153 VPWR VGND VPWR VGND sky130_ef_sc_hd__decap_12
XFILLER_0_90_197 VPWR VGND VPWR VGND sky130_ef_sc_hd__decap_12
XFILLER_0_7_3 VPWR VGND VPWR VGND sky130_ef_sc_hd__decap_12
XFILLER_0_86_404 VGND VGND VPWR VPWR sky130_fd_sc_hd__decap_4
XFILLER_0_86_448 VPWR VGND VPWR VGND sky130_ef_sc_hd__decap_12
XFILLER_0_39_353 VGND VGND VPWR VPWR sky130_fd_sc_hd__fill_2
XFILLER_0_66_183 VGND VGND VPWR VPWR sky130_fd_sc_hd__fill_1
XFILLER_0_89_39 VPWR VGND VPWR VGND sky130_ef_sc_hd__decap_12
XFILLER_0_22_253 VGND VGND VPWR VPWR sky130_fd_sc_hd__decap_4
X_2580_ _0740_ _0955_ _1433_ _1432_ net62 VGND VGND VPWR VPWR _0292_ sky130_fd_sc_hd__a32o_1
XFILLER_0_1_169 VGND VGND VPWR VPWR sky130_fd_sc_hd__decap_8
XFILLER_0_22_297 VGND VGND VPWR VPWR sky130_fd_sc_hd__fill_1
X_4250_ clknet_leaf_2_clock _0064_ VGND VGND VPWR VPWR fifo3.mem\[1\]\[2\] sky130_fd_sc_hd__dfxtp_1
X_4181_ _1060_ _1059_ VGND VGND VPWR VPWR _1061_ sky130_fd_sc_hd__nand2_1
X_3201_ fifo3.mem\[11\]\[2\] _1830_ VGND VGND VPWR VPWR _1831_ sky130_fd_sc_hd__and2b_1
X_3132_ _0927_ _1789_ _1792_ VGND VGND VPWR VPWR _0485_ sky130_fd_sc_hd__o21a_1
X_3063_ _1752_ VGND VGND VPWR VPWR _1753_ sky130_fd_sc_hd__buf_2
XFILLER_0_77_426 VGND VGND VPWR VPWR sky130_fd_sc_hd__fill_2
XFILLER_0_9_225 VPWR VGND VPWR VGND sky130_ef_sc_hd__decap_12
X_3965_ net3 regis.fifo_full_state\[2\] _0910_ VGND VGND VPWR VPWR _0913_ sky130_fd_sc_hd__mux2_1
X_2916_ fifo2.count\[2\] fifo2.count\[1\] fifo2.count\[0\] VGND VGND VPWR VPWR _1620_
+ sky130_fd_sc_hd__or3_2
X_3896_ _0855_ _0856_ fifo2.mem\[8\]\[5\] _0857_ _0866_ VGND VGND VPWR VPWR _0076_
+ sky130_fd_sc_hd__a32o_1
XFILLER_0_72_164 VGND VGND VPWR VPWR sky130_fd_sc_hd__fill_1
X_2847_ _1538_ _1543_ _1546_ _1549_ _1552_ VGND VGND VPWR VPWR _1553_ sky130_fd_sc_hd__a32oi_4
XFILLER_0_85_3 VPWR VGND VPWR VGND sky130_ef_sc_hd__decap_12
XFILLER_0_72_197 VGND VGND VPWR VPWR sky130_fd_sc_hd__decap_3
XFILLER_0_5_453 VGND VGND VPWR VPWR sky130_fd_sc_hd__fill_1
Xhold110 fifo1.mem\[8\]\[4\] VGND VGND VPWR VPWR net158 sky130_fd_sc_hd__dlygate4sd3_1
X_2778_ _0961_ _1090_ _0972_ VGND VGND VPWR VPWR _1499_ sky130_fd_sc_hd__a21oi_1
X_4517_ clknet_leaf_24_clock _0323_ VGND VGND VPWR VPWR fifo2.mem\[4\]\[0\] sky130_fd_sc_hd__dfxtp_1
Xhold121 fifo2.mem\[13\]\[0\] VGND VGND VPWR VPWR net169 sky130_fd_sc_hd__dlygate4sd3_1
Xhold143 fifo2.mem\[12\]\[6\] VGND VGND VPWR VPWR net191 sky130_fd_sc_hd__dlygate4sd3_1
Xhold132 fifo1.mem\[4\]\[3\] VGND VGND VPWR VPWR net180 sky130_fd_sc_hd__dlygate4sd3_1
Xhold176 fifo3.mem\[3\]\[4\] VGND VGND VPWR VPWR net224 sky130_fd_sc_hd__dlygate4sd3_1
Xhold165 fifo2.mem\[14\]\[2\] VGND VGND VPWR VPWR net213 sky130_fd_sc_hd__dlygate4sd3_1
Xhold154 fifo2.mem\[9\]\[3\] VGND VGND VPWR VPWR net202 sky130_fd_sc_hd__dlygate4sd3_1
X_4448_ clknet_leaf_20_clock _0254_ VGND VGND VPWR VPWR fifo1.rd_pointer\[1\] sky130_fd_sc_hd__dfxtp_2
Xhold187 fifo1.mem\[15\]\[6\] VGND VGND VPWR VPWR net235 sky130_fd_sc_hd__dlygate4sd3_1
Xhold198 fifo3.mem\[0\]\[7\] VGND VGND VPWR VPWR net246 sky130_fd_sc_hd__dlygate4sd3_1
X_4379_ clknet_leaf_8_clock _0193_ VGND VGND VPWR VPWR fifo1.mem\[9\]\[8\] sky130_fd_sc_hd__dfxtp_1
XTAP_470 VGND VPWR sky130_fd_sc_hd__tapvpwrvgnd_1
XTAP_481 VGND VPWR sky130_fd_sc_hd__tapvpwrvgnd_1
XTAP_492 VGND VPWR sky130_fd_sc_hd__tapvpwrvgnd_1
XFILLER_0_36_345 VGND VGND VPWR VPWR sky130_fd_sc_hd__fill_1
XFILLER_0_48_194 VGND VGND VPWR VPWR sky130_fd_sc_hd__fill_2
XFILLER_0_91_473 VGND VGND VPWR VPWR sky130_fd_sc_hd__decap_3
XFILLER_0_63_197 VGND VGND VPWR VPWR sky130_fd_sc_hd__decap_3
XFILLER_0_91_29 VPWR VGND VPWR VGND sky130_ef_sc_hd__decap_12
XFILLER_0_86_212 VPWR VGND VPWR VGND sky130_ef_sc_hd__decap_12
XFILLER_0_24_45 VGND VGND VPWR VPWR sky130_fd_sc_hd__fill_1
XFILLER_0_86_289 VGND VGND VPWR VPWR sky130_fd_sc_hd__decap_3
XFILLER_0_24_78 VGND VGND VPWR VPWR sky130_fd_sc_hd__decap_6
XFILLER_0_39_150 VGND VGND VPWR VPWR sky130_fd_sc_hd__decap_3
XFILLER_0_39_172 VPWR VGND VPWR VGND sky130_ef_sc_hd__decap_12
X_3750_ _0733_ VGND VGND VPWR VPWR _0760_ sky130_fd_sc_hd__buf_4
XFILLER_0_67_492 VGND VGND VPWR VPWR sky130_fd_sc_hd__decap_4
XFILLER_0_27_378 VGND VGND VPWR VPWR sky130_fd_sc_hd__fill_2
X_2701_ _0858_ _0972_ _0716_ _0954_ VGND VGND VPWR VPWR _1479_ sky130_fd_sc_hd__and4_1
X_3681_ syn.count0\[3\] _0703_ VGND VGND VPWR VPWR _0705_ sky130_fd_sc_hd__nand2_1
XFILLER_0_15_529 VGND VGND VPWR VPWR sky130_fd_sc_hd__decap_8
XFILLER_0_54_197 VPWR VGND VPWR VGND sky130_ef_sc_hd__decap_12
XFILLER_0_2_401 VPWR VGND VPWR VGND sky130_ef_sc_hd__decap_12
X_2632_ _1445_ VGND VGND VPWR VPWR _1446_ sky130_fd_sc_hd__clkbuf_4
X_2563_ _0713_ _1426_ _1429_ _1430_ net269 VGND VGND VPWR VPWR _0278_ sky130_fd_sc_hd__a32o_1
XFILLER_0_2_489 VPWR VGND VPWR VGND sky130_ef_sc_hd__decap_12
X_4302_ clknet_leaf_0_clock _0116_ VGND VGND VPWR VPWR fifo3.mem\[6\]\[2\] sky130_fd_sc_hd__dfxtp_1
XFILLER_0_49_64 VGND VGND VPWR VPWR sky130_fd_sc_hd__decap_4
XFILLER_0_10_278 VGND VGND VPWR VPWR sky130_fd_sc_hd__decap_8
X_4233_ clknet_leaf_1_clock _0047_ VGND VGND VPWR VPWR fifo3.mem\[7\]\[3\] sky130_fd_sc_hd__dfxtp_1
X_2494_ _1232_ fifo1.mem\[8\]\[7\] _1182_ VGND VGND VPWR VPWR _1377_ sky130_fd_sc_hd__o21ba_1
X_4164_ _1048_ regis.internal_parity\[3\] _1042_ VGND VGND VPWR VPWR _1049_ sky130_fd_sc_hd__a21boi_1
X_3115_ _0932_ _1771_ _1782_ VGND VGND VPWR VPWR _0478_ sky130_fd_sc_hd__a21o_1
XFILLER_0_4_77 VGND VGND VPWR VPWR sky130_fd_sc_hd__decap_6
X_4095_ _0993_ fifo1.data_in\[1\] VGND VGND VPWR VPWR _0999_ sky130_fd_sc_hd__or2b_1
XFILLER_0_65_74 VGND VGND VPWR VPWR sky130_fd_sc_hd__fill_1
X_3046_ _1553_ _1733_ VGND VGND VPWR VPWR _1746_ sky130_fd_sc_hd__nand2_1
XFILLER_0_18_301 VGND VGND VPWR VPWR sky130_fd_sc_hd__decap_6
X_3948_ syn.count2\[0\] syn.count2\[1\] syn.count2\[3\] syn.count2\[2\] VGND VGND
+ VPWR VPWR _0902_ sky130_fd_sc_hd__and4_1
XFILLER_0_45_153 VGND VGND VPWR VPWR sky130_fd_sc_hd__decap_4
XFILLER_0_73_473 VPWR VGND VPWR VGND sky130_ef_sc_hd__decap_12
X_3879_ _0851_ _0854_ VGND VGND VPWR VPWR _0855_ sky130_fd_sc_hd__nand2_2
XFILLER_0_45_164 VGND VGND VPWR VPWR sky130_fd_sc_hd__decap_4
XFILLER_0_45_175 VGND VGND VPWR VPWR sky130_fd_sc_hd__fill_1
XFILLER_0_5_294 VGND VGND VPWR VPWR sky130_fd_sc_hd__fill_1
XFILLER_0_91_281 VPWR VGND VPWR VGND sky130_ef_sc_hd__decap_12
XFILLER_0_36_175 VGND VGND VPWR VPWR sky130_fd_sc_hd__decap_4
XFILLER_0_51_167 VGND VGND VPWR VPWR sky130_fd_sc_hd__fill_1
XFILLER_0_86_29 VPWR VGND VPWR VGND sky130_ef_sc_hd__decap_12
XFILLER_0_35_11 VGND VGND VPWR VPWR sky130_fd_sc_hd__decap_3
X_3802_ _0767_ VGND VGND VPWR VPWR _0797_ sky130_fd_sc_hd__buf_4
X_4782_ clknet_leaf_47_clock _0588_ VGND VGND VPWR VPWR fifo3.mem\[12\]\[1\] sky130_fd_sc_hd__dfxtp_1
XFILLER_0_27_131 VGND VGND VPWR VPWR sky130_fd_sc_hd__fill_2
XFILLER_0_82_281 VGND VGND VPWR VPWR sky130_fd_sc_hd__fill_1
XFILLER_0_42_101 VPWR VGND VPWR VGND sky130_ef_sc_hd__decap_12
X_3733_ _0714_ VGND VGND VPWR VPWR _0746_ sky130_fd_sc_hd__clkbuf_4
XFILLER_0_82_292 VGND VGND VPWR VPWR sky130_fd_sc_hd__fill_2
X_3664_ _0652_ VGND VGND VPWR VPWR _0693_ sky130_fd_sc_hd__buf_4
XFILLER_0_30_307 VGND VGND VPWR VPWR sky130_fd_sc_hd__fill_1
X_2615_ _0740_ _0870_ _1431_ _1441_ net325 VGND VGND VPWR VPWR _0319_ sky130_fd_sc_hd__a32o_1
XFILLER_0_70_465 VGND VGND VPWR VPWR sky130_fd_sc_hd__fill_1
XFILLER_0_2_253 VGND VGND VPWR VPWR sky130_fd_sc_hd__decap_3
X_3595_ _0631_ _0632_ VGND VGND VPWR VPWR _0633_ sky130_fd_sc_hd__nor2_4
X_2546_ _0759_ _1416_ _0830_ _1421_ VGND VGND VPWR VPWR _0270_ sky130_fd_sc_hd__a31o_1
X_2477_ _1317_ _1294_ _1297_ VGND VGND VPWR VPWR _1360_ sky130_fd_sc_hd__a21o_1
XFILLER_0_48_3 VGND VGND VPWR VPWR sky130_fd_sc_hd__decap_6
X_4216_ clknet_leaf_34_clock _0030_ VGND VGND VPWR VPWR fifo2.mem\[3\]\[4\] sky130_fd_sc_hd__dfxtp_1
XFILLER_0_76_95 VGND VGND VPWR VPWR sky130_fd_sc_hd__decap_3
X_4147_ net7 _1027_ _1035_ _1037_ VGND VGND VPWR VPWR _0156_ sky130_fd_sc_hd__o211a_1
X_4078_ _0983_ _0684_ VGND VGND VPWR VPWR _0984_ sky130_fd_sc_hd__and2_1
X_3029_ _1729_ _1623_ VGND VGND VPWR VPWR _1730_ sky130_fd_sc_hd__nand2_1
XFILLER_0_38_429 VGND VGND VPWR VPWR sky130_fd_sc_hd__decap_4
XFILLER_0_18_153 VGND VGND VPWR VPWR sky130_fd_sc_hd__fill_2
XFILLER_0_80_229 VGND VGND VPWR VPWR sky130_fd_sc_hd__fill_1
XFILLER_0_73_281 VGND VGND VPWR VPWR sky130_fd_sc_hd__decap_6
XFILLER_0_18_197 VGND VGND VPWR VPWR sky130_fd_sc_hd__fill_1
XFILLER_0_61_476 VGND VGND VPWR VPWR sky130_fd_sc_hd__fill_1
XFILLER_0_84_513 VPWR VGND VPWR VGND sky130_ef_sc_hd__decap_12
XFILLER_0_52_421 VPWR VGND VPWR VGND sky130_ef_sc_hd__decap_12
XFILLER_0_21_57 VGND VGND VPWR VPWR sky130_fd_sc_hd__decap_6
XFILLER_0_52_465 VGND VGND VPWR VPWR sky130_fd_sc_hd__decap_4
X_2400_ fifo1.count\[2\] fifo1.count\[1\] fifo1.count\[0\] VGND VGND VPWR VPWR _1286_
+ sky130_fd_sc_hd__or3_2
X_3380_ _1993_ _1623_ _1538_ VGND VGND VPWR VPWR _1994_ sky130_fd_sc_hd__a21o_1
X_2331_ _1218_ _0002_ _1197_ VGND VGND VPWR VPWR _1219_ sky130_fd_sc_hd__a21oi_2
XFILLER_0_20_384 VPWR VGND VPWR VGND sky130_ef_sc_hd__decap_12
X_2262_ fifo1.rd_pointer\[0\] VGND VGND VPWR VPWR _1155_ sky130_fd_sc_hd__buf_2
X_4001_ _0928_ _0786_ fifo3.mem\[5\]\[6\] VGND VGND VPWR VPWR _0937_ sky130_fd_sc_hd__and3_1
XFILLER_0_34_9 VPWR VGND VPWR VGND sky130_ef_sc_hd__decap_12
X_2193_ _0768_ _1117_ _1118_ net266 VGND VGND VPWR VPWR _0220_ sky130_fd_sc_hd__a22o_1
XFILLER_0_87_373 VPWR VGND VPWR VGND sky130_ef_sc_hd__decap_12
X_4765_ clknet_leaf_57_clock _0571_ VGND VGND VPWR VPWR fifo3.mem\[10\]\[2\] sky130_fd_sc_hd__dfxtp_1
XFILLER_0_7_334 VGND VGND VPWR VPWR sky130_fd_sc_hd__fill_2
XFILLER_0_28_473 VGND VGND VPWR VPWR sky130_fd_sc_hd__decap_3
XFILLER_0_43_443 VGND VGND VPWR VPWR sky130_fd_sc_hd__decap_4
XFILLER_0_55_281 VGND VGND VPWR VPWR sky130_fd_sc_hd__fill_1
X_3716_ _0734_ _0715_ _0724_ _0730_ net49 VGND VGND VPWR VPWR _0028_ sky130_fd_sc_hd__a32o_1
X_4696_ clknet_leaf_19_clock _0502_ VGND VGND VPWR VPWR fifo1.mem\[15\]\[6\] sky130_fd_sc_hd__dfxtp_1
XFILLER_0_15_178 VGND VGND VPWR VPWR sky130_fd_sc_hd__decap_3
X_3647_ fsm1.ld_state VGND VGND VPWR VPWR _0681_ sky130_fd_sc_hd__clkbuf_4
XFILLER_0_15_189 VGND VGND VPWR VPWR sky130_fd_sc_hd__fill_2
X_3578_ _0605_ _0610_ _0616_ VGND VGND VPWR VPWR _0617_ sky130_fd_sc_hd__nand3b_4
XFILLER_0_87_72 VGND VGND VPWR VPWR sky130_fd_sc_hd__fill_2
X_2529_ _1408_ VGND VGND VPWR VPWR _0266_ sky130_fd_sc_hd__clkbuf_1
Xhold14 fifo2.mem\[13\]\[5\] VGND VGND VPWR VPWR net62 sky130_fd_sc_hd__dlygate4sd3_1
Xhold47 fifo1.mem\[12\]\[4\] VGND VGND VPWR VPWR net95 sky130_fd_sc_hd__dlygate4sd3_1
Xhold25 fifo3.mem\[1\]\[0\] VGND VGND VPWR VPWR net73 sky130_fd_sc_hd__dlygate4sd3_1
Xhold36 fifo1.mem\[5\]\[1\] VGND VGND VPWR VPWR net84 sky130_fd_sc_hd__dlygate4sd3_1
Xhold69 fifo1.mem\[4\]\[8\] VGND VGND VPWR VPWR net117 sky130_fd_sc_hd__dlygate4sd3_1
Xhold58 fifo1.mem\[3\]\[4\] VGND VGND VPWR VPWR net106 sky130_fd_sc_hd__dlygate4sd3_1
XFILLER_0_81_505 VPWR VGND VPWR VGND sky130_ef_sc_hd__decap_12
XFILLER_0_19_473 VGND VGND VPWR VPWR sky130_fd_sc_hd__decap_6
XFILLER_0_16_79 VGND VGND VPWR VPWR sky130_fd_sc_hd__decap_4
XTAP_1071 VGND VPWR sky130_fd_sc_hd__tapvpwrvgnd_1
XTAP_1060 VGND VPWR sky130_fd_sc_hd__tapvpwrvgnd_1
XFILLER_0_84_365 VPWR VGND VPWR VGND sky130_ef_sc_hd__decap_12
XFILLER_0_29_248 VGND VGND VPWR VPWR sky130_fd_sc_hd__fill_2
X_2880_ fifo2.mem\[11\]\[2\] _1582_ _1585_ VGND VGND VPWR VPWR _1586_ sky130_fd_sc_hd__o21ai_1
XFILLER_0_72_527 VGND VGND VPWR VPWR sky130_fd_sc_hd__decap_4
XFILLER_0_25_432 VGND VGND VPWR VPWR sky130_fd_sc_hd__decap_3
XFILLER_0_37_281 VPWR VGND VPWR VGND sky130_ef_sc_hd__decap_12
X_4550_ clknet_leaf_15_clock _0356_ VGND VGND VPWR VPWR fifo1.mem\[13\]\[6\] sky130_fd_sc_hd__dfxtp_1
XFILLER_0_52_251 VGND VGND VPWR VPWR sky130_fd_sc_hd__fill_1
XFILLER_0_12_104 VGND VGND VPWR VPWR sky130_fd_sc_hd__decap_3
X_4481_ clknet_leaf_38_clock _0287_ VGND VGND VPWR VPWR fifo2.mem\[13\]\[0\] sky130_fd_sc_hd__dfxtp_1
X_3501_ _0737_ _0746_ _0871_ _2081_ net151 VGND VGND VPWR VPWR _0564_ sky130_fd_sc_hd__a32o_1
XFILLER_0_52_295 VGND VGND VPWR VPWR sky130_fd_sc_hd__decap_6
XFILLER_0_40_446 VGND VGND VPWR VPWR sky130_fd_sc_hd__decap_6
X_3432_ fifo3.count\[2\] fifo3.count\[1\] fifo3.count\[0\] VGND VGND VPWR VPWR _2036_
+ sky130_fd_sc_hd__or3_1
X_3363_ _0785_ _1983_ _0921_ VGND VGND VPWR VPWR _0525_ sky130_fd_sc_hd__a21oi_1
XTAP_800 VGND VPWR sky130_fd_sc_hd__tapvpwrvgnd_1
XTAP_811 VGND VPWR sky130_fd_sc_hd__tapvpwrvgnd_1
XTAP_822 VGND VPWR sky130_fd_sc_hd__tapvpwrvgnd_1
XTAP_833 VGND VPWR sky130_fd_sc_hd__tapvpwrvgnd_1
XTAP_844 VGND VPWR sky130_fd_sc_hd__tapvpwrvgnd_1
X_2314_ _1201_ _1191_ _1181_ VGND VGND VPWR VPWR _1202_ sky130_fd_sc_hd__a21oi_2
XTAP_877 VGND VPWR sky130_fd_sc_hd__tapvpwrvgnd_1
X_3294_ _1849_ fifo3.mem\[6\]\[5\] _1806_ VGND VGND VPWR VPWR _1921_ sky130_fd_sc_hd__o21ai_1
XTAP_855 VGND VPWR sky130_fd_sc_hd__tapvpwrvgnd_1
XTAP_866 VGND VPWR sky130_fd_sc_hd__tapvpwrvgnd_1
X_2245_ _1109_ _1141_ _1144_ net149 VGND VGND VPWR VPWR _0246_ sky130_fd_sc_hd__a22o_1
XTAP_899 VGND VPWR sky130_fd_sc_hd__tapvpwrvgnd_1
XTAP_888 VGND VPWR sky130_fd_sc_hd__tapvpwrvgnd_1
X_2176_ _1105_ _1114_ _1115_ net256 VGND VGND VPWR VPWR _0206_ sky130_fd_sc_hd__a22o_1
XFILLER_0_79_137 VGND VGND VPWR VPWR sky130_fd_sc_hd__decap_4
XFILLER_0_63_505 VGND VGND VPWR VPWR sky130_fd_sc_hd__decap_8
XFILLER_0_7_131 VPWR VGND VPWR VGND sky130_ef_sc_hd__decap_12
XFILLER_0_35_229 VGND VGND VPWR VPWR sky130_fd_sc_hd__fill_1
XFILLER_0_90_357 VGND VGND VPWR VPWR sky130_fd_sc_hd__decap_6
XFILLER_0_16_421 VGND VGND VPWR VPWR sky130_fd_sc_hd__decap_8
X_4748_ clknet_leaf_4_clock _0554_ VGND VGND VPWR VPWR fifo3.mem\[0\]\[3\] sky130_fd_sc_hd__dfxtp_1
X_4679_ clknet_leaf_62_clock _0485_ VGND VGND VPWR VPWR fifo3.mem\[4\]\[2\] sky130_fd_sc_hd__dfxtp_1
XFILLER_0_43_273 VGND VGND VPWR VPWR sky130_fd_sc_hd__fill_1
Xoutput15 net15 VGND VGND VPWR VPWR data_out_0[0] sky130_fd_sc_hd__clkbuf_4
XFILLER_0_31_479 VPWR VGND VPWR VGND sky130_ef_sc_hd__decap_12
Xoutput26 net26 VGND VGND VPWR VPWR data_out_1[3] sky130_fd_sc_hd__clkbuf_4
Xoutput37 net37 VGND VGND VPWR VPWR data_out_2[6] sky130_fd_sc_hd__clkbuf_4
XPHY_143 VGND VGND VPWR VPWR sky130_fd_sc_hd__decap_3
XPHY_110 VGND VGND VPWR VPWR sky130_fd_sc_hd__decap_3
XPHY_121 VGND VGND VPWR VPWR sky130_fd_sc_hd__decap_3
XPHY_132 VGND VGND VPWR VPWR sky130_fd_sc_hd__decap_3
XPHY_176 VGND VGND VPWR VPWR sky130_fd_sc_hd__decap_3
XPHY_165 VGND VGND VPWR VPWR sky130_fd_sc_hd__decap_3
XPHY_154 VGND VGND VPWR VPWR sky130_fd_sc_hd__decap_3
XFILLER_0_54_538 VGND VGND VPWR VPWR sky130_fd_sc_hd__decap_3
XFILLER_0_81_335 VGND VGND VPWR VPWR sky130_fd_sc_hd__fill_1
XFILLER_0_34_251 VGND VGND VPWR VPWR sky130_fd_sc_hd__fill_1
XFILLER_0_89_435 VPWR VGND VPWR VGND sky130_ef_sc_hd__decap_12
XPHY_1 VGND VGND VPWR VPWR sky130_fd_sc_hd__decap_3
X_3981_ _0770_ _0776_ _0781_ _0824_ VGND VGND VPWR VPWR _0923_ sky130_fd_sc_hd__and4_1
XFILLER_0_43_55 VGND VGND VPWR VPWR sky130_fd_sc_hd__fill_1
X_2932_ fifo2.mem\[15\]\[4\] _1582_ _1635_ VGND VGND VPWR VPWR _1636_ sky130_fd_sc_hd__o21ai_1
XFILLER_0_17_207 VGND VGND VPWR VPWR sky130_fd_sc_hd__fill_1
XFILLER_0_45_505 VPWR VGND VPWR VGND sky130_ef_sc_hd__decap_12
XFILLER_0_72_335 VGND VGND VPWR VPWR sky130_fd_sc_hd__decap_4
X_2863_ _0004_ VGND VGND VPWR VPWR _1569_ sky130_fd_sc_hd__clkbuf_4
Xclkbuf_leaf_61_clock clknet_3_0__leaf_clock VGND VGND VPWR VPWR clknet_leaf_61_clock
+ sky130_fd_sc_hd__clkbuf_16
XFILLER_0_4_123 VGND VGND VPWR VPWR sky130_fd_sc_hd__fill_1
X_2794_ _1511_ VGND VGND VPWR VPWR _0428_ sky130_fd_sc_hd__clkbuf_1
X_4602_ clknet_leaf_11_clock _0408_ VGND VGND VPWR VPWR fifo1.mem\[1\]\[4\] sky130_fd_sc_hd__dfxtp_1
X_4533_ clknet_leaf_24_clock _0339_ VGND VGND VPWR VPWR fifo2.mem\[7\]\[7\] sky130_fd_sc_hd__dfxtp_1
XFILLER_0_4_167 VGND VGND VPWR VPWR sky130_fd_sc_hd__decap_3
XFILLER_0_13_468 VGND VGND VPWR VPWR sky130_fd_sc_hd__decap_8
XFILLER_0_7_55 VGND VGND VPWR VPWR sky130_fd_sc_hd__fill_1
X_4464_ clknet_leaf_2_clock _0270_ VGND VGND VPWR VPWR fifo3.mem\[3\]\[1\] sky130_fd_sc_hd__dfxtp_1
X_4395_ clknet_leaf_12_clock _0209_ VGND VGND VPWR VPWR fifo1.mem\[2\]\[6\] sky130_fd_sc_hd__dfxtp_1
X_3415_ _2020_ fifo3.count\[0\] VGND VGND VPWR VPWR _2021_ sky130_fd_sc_hd__and2_1
XFILLER_0_68_85 VGND VGND VPWR VPWR sky130_fd_sc_hd__fill_1
X_3346_ _1942_ fifo3.mem\[9\]\[7\] _1970_ VGND VGND VPWR VPWR _1971_ sky130_fd_sc_hd__o21ai_1
XTAP_630 VGND VPWR sky130_fd_sc_hd__tapvpwrvgnd_1
XTAP_641 VGND VPWR sky130_fd_sc_hd__tapvpwrvgnd_1
XTAP_652 VGND VPWR sky130_fd_sc_hd__tapvpwrvgnd_1
XTAP_663 VGND VPWR sky130_fd_sc_hd__tapvpwrvgnd_1
XTAP_674 VGND VPWR sky130_fd_sc_hd__tapvpwrvgnd_1
XTAP_685 VGND VPWR sky130_fd_sc_hd__tapvpwrvgnd_1
XFILLER_0_30_3 VPWR VGND VPWR VGND sky130_ef_sc_hd__decap_12
X_3277_ fifo3.mem\[1\]\[4\] _1804_ VGND VGND VPWR VPWR _1905_ sky130_fd_sc_hd__and2b_1
XTAP_696 VGND VPWR sky130_fd_sc_hd__tapvpwrvgnd_1
X_2228_ net337 _1137_ _1139_ _0932_ VGND VGND VPWR VPWR _0234_ sky130_fd_sc_hd__a22o_1
X_2159_ _1106_ _1101_ _1103_ net116 VGND VGND VPWR VPWR _0198_ sky130_fd_sc_hd__a22o_1
Xclkbuf_leaf_14_clock clknet_3_2__leaf_clock VGND VGND VPWR VPWR clknet_leaf_14_clock
+ sky130_fd_sc_hd__clkbuf_16
XFILLER_0_48_365 VGND VGND VPWR VPWR sky130_fd_sc_hd__decap_8
XFILLER_0_90_121 VPWR VGND VPWR VGND sky130_ef_sc_hd__decap_12
Xclkbuf_leaf_29_clock clknet_3_7__leaf_clock VGND VGND VPWR VPWR clknet_leaf_29_clock
+ sky130_fd_sc_hd__clkbuf_16
XFILLER_0_90_165 VPWR VGND VPWR VGND sky130_ef_sc_hd__decap_12
XFILLER_0_16_251 VGND VGND VPWR VPWR sky130_fd_sc_hd__fill_1
XFILLER_0_71_390 VGND VGND VPWR VPWR sky130_fd_sc_hd__fill_2
XFILLER_0_27_505 VPWR VGND VPWR VGND sky130_ef_sc_hd__decap_12
XFILLER_0_22_210 VGND VGND VPWR VPWR sky130_fd_sc_hd__fill_2
XFILLER_0_22_265 VPWR VGND VPWR VGND sky130_ef_sc_hd__decap_12
X_4180_ regis.packet_parity\[0\] VGND VGND VPWR VPWR _1060_ sky130_fd_sc_hd__inv_2
X_3200_ _0008_ VGND VGND VPWR VPWR _1830_ sky130_fd_sc_hd__clkbuf_4
X_3131_ fifo3.mem\[4\]\[2\] _0842_ _1788_ VGND VGND VPWR VPWR _1792_ sky130_fd_sc_hd__a21bo_1
X_3062_ fifo3.wr_pointer\[3\] _0784_ _0780_ VGND VGND VPWR VPWR _1752_ sky130_fd_sc_hd__and3_1
X_3964_ _0912_ VGND VGND VPWR VPWR _0098_ sky130_fd_sc_hd__clkbuf_1
XFILLER_0_9_237 VGND VGND VPWR VPWR sky130_fd_sc_hd__decap_8
X_2915_ net41 net11 VGND VGND VPWR VPWR _1619_ sky130_fd_sc_hd__and2_1
X_3895_ _0725_ _0858_ fifo1.data_in\[5\] _0860_ VGND VGND VPWR VPWR _0866_ sky130_fd_sc_hd__and4b_1
XFILLER_0_57_173 VGND VGND VPWR VPWR sky130_fd_sc_hd__fill_1
XFILLER_0_5_421 VGND VGND VPWR VPWR sky130_fd_sc_hd__fill_1
X_2846_ _1551_ _1542_ VGND VGND VPWR VPWR _1552_ sky130_fd_sc_hd__nand2_1
XFILLER_0_78_3 VGND VGND VPWR VPWR sky130_fd_sc_hd__decap_3
Xhold100 fifo1.mem\[11\]\[6\] VGND VGND VPWR VPWR net148 sky130_fd_sc_hd__dlygate4sd3_1
X_2777_ _0961_ _1090_ _1498_ VGND VGND VPWR VPWR _0424_ sky130_fd_sc_hd__o21ba_1
X_4516_ clknet_leaf_33_clock _0322_ VGND VGND VPWR VPWR fifo2.mem\[9\]\[8\] sky130_fd_sc_hd__dfxtp_1
Xhold133 fifo2.mem\[14\]\[5\] VGND VGND VPWR VPWR net181 sky130_fd_sc_hd__dlygate4sd3_1
Xhold144 fifo1.mem\[5\]\[3\] VGND VGND VPWR VPWR net192 sky130_fd_sc_hd__dlygate4sd3_1
Xhold111 fifo1.mem\[3\]\[3\] VGND VGND VPWR VPWR net159 sky130_fd_sc_hd__dlygate4sd3_1
Xhold122 fifo1.mem\[0\]\[3\] VGND VGND VPWR VPWR net170 sky130_fd_sc_hd__dlygate4sd3_1
Xhold177 fifo1.mem\[0\]\[6\] VGND VGND VPWR VPWR net225 sky130_fd_sc_hd__dlygate4sd3_1
Xhold155 fifo3.mem\[14\]\[3\] VGND VGND VPWR VPWR net203 sky130_fd_sc_hd__dlygate4sd3_1
X_4447_ clknet_leaf_20_clock _0253_ VGND VGND VPWR VPWR fifo1.rd_pointer\[0\] sky130_fd_sc_hd__dfxtp_1
Xhold166 fifo1.mem\[12\]\[3\] VGND VGND VPWR VPWR net214 sky130_fd_sc_hd__dlygate4sd3_1
XFILLER_0_0_181 VPWR VGND VPWR VGND sky130_ef_sc_hd__decap_12
Xhold199 fifo2.mem\[15\]\[8\] VGND VGND VPWR VPWR net247 sky130_fd_sc_hd__dlygate4sd3_1
Xhold188 fifo1.mem\[10\]\[7\] VGND VGND VPWR VPWR net236 sky130_fd_sc_hd__dlygate4sd3_1
XTAP_460 VGND VPWR sky130_fd_sc_hd__tapvpwrvgnd_1
X_4378_ clknet_leaf_9_clock _0192_ VGND VGND VPWR VPWR fifo1.mem\[9\]\[7\] sky130_fd_sc_hd__dfxtp_1
X_3329_ _1942_ fifo3.mem\[5\]\[6\] _1954_ VGND VGND VPWR VPWR _1955_ sky130_fd_sc_hd__o21ai_1
XTAP_471 VGND VPWR sky130_fd_sc_hd__tapvpwrvgnd_1
XTAP_482 VGND VPWR sky130_fd_sc_hd__tapvpwrvgnd_1
XTAP_493 VGND VPWR sky130_fd_sc_hd__tapvpwrvgnd_1
XFILLER_0_91_485 VPWR VGND VPWR VGND sky130_ef_sc_hd__decap_12
XFILLER_0_8_292 VGND VGND VPWR VPWR sky130_fd_sc_hd__fill_2
XFILLER_0_51_316 VGND VGND VPWR VPWR sky130_fd_sc_hd__decap_4
XFILLER_0_86_224 VPWR VGND VPWR VGND sky130_ef_sc_hd__decap_12
XFILLER_0_59_449 VGND VGND VPWR VPWR sky130_fd_sc_hd__decap_8
XFILLER_0_67_471 VGND VGND VPWR VPWR sky130_fd_sc_hd__decap_8
XFILLER_0_39_184 VGND VGND VPWR VPWR sky130_fd_sc_hd__decap_8
X_2700_ _1477_ VGND VGND VPWR VPWR _1478_ sky130_fd_sc_hd__buf_2
X_3680_ syn.count0\[0\] syn.count0\[1\] syn.count0\[2\] syn.count0\[3\] VGND VGND
+ VPWR VPWR _0704_ sky130_fd_sc_hd__a31o_1
XFILLER_0_2_413 VGND VGND VPWR VPWR sky130_fd_sc_hd__decap_6
X_2631_ _1090_ _0717_ _0716_ VGND VGND VPWR VPWR _1445_ sky130_fd_sc_hd__and3_1
X_2562_ _1424_ _1428_ _0974_ VGND VGND VPWR VPWR _1430_ sky130_fd_sc_hd__a21oi_4
X_4301_ clknet_leaf_61_clock _0115_ VGND VGND VPWR VPWR fifo3.mem\[6\]\[1\] sky130_fd_sc_hd__dfxtp_1
XFILLER_0_50_393 VGND VGND VPWR VPWR sky130_fd_sc_hd__fill_1
XFILLER_0_10_268 VGND VGND VPWR VPWR sky130_fd_sc_hd__fill_2
X_4232_ clknet_leaf_2_clock _0046_ VGND VGND VPWR VPWR fifo3.mem\[7\]\[2\] sky130_fd_sc_hd__dfxtp_1
X_2493_ fifo1.mem\[11\]\[7\] _1220_ _1183_ VGND VGND VPWR VPWR _1376_ sky130_fd_sc_hd__o21ai_1
X_4163_ regis.header_byte\[3\] _0993_ _1040_ net4 VGND VGND VPWR VPWR _1048_ sky130_fd_sc_hd__a22o_1
X_3114_ _0839_ _1779_ _1781_ fifo3.mem\[9\]\[4\] _1775_ VGND VGND VPWR VPWR _1782_
+ sky130_fd_sc_hd__o311a_1
X_4094_ _0658_ _0986_ _0989_ _0997_ VGND VGND VPWR VPWR _0998_ sky130_fd_sc_hd__o211ai_1
XFILLER_0_65_97 VPWR VGND VPWR VGND sky130_ef_sc_hd__decap_12
X_3045_ fifo2.count\[6\] _1744_ _1503_ _1508_ VGND VGND VPWR VPWR _1745_ sky130_fd_sc_hd__o2bb2a_1
XFILLER_0_81_30 VPWR VGND VPWR VGND sky130_ef_sc_hd__decap_12
X_3947_ _0901_ VGND VGND VPWR VPWR _0092_ sky130_fd_sc_hd__clkbuf_1
XFILLER_0_73_485 VGND VGND VPWR VPWR sky130_fd_sc_hd__decap_4
X_3878_ _0619_ _0719_ _0853_ fifo2.wr_pointer\[3\] VGND VGND VPWR VPWR _0854_ sky130_fd_sc_hd__and4b_2
X_2829_ _1388_ _1535_ _0694_ VGND VGND VPWR VPWR _1536_ sky130_fd_sc_hd__and3b_1
XFILLER_0_14_530 VGND VGND VPWR VPWR sky130_fd_sc_hd__fill_2
XFILLER_0_60_157 VGND VGND VPWR VPWR sky130_fd_sc_hd__fill_1
XFILLER_0_41_393 VPWR VGND VPWR VGND sky130_ef_sc_hd__decap_12
XTAP_290 VGND VPWR sky130_fd_sc_hd__tapvpwrvgnd_1
XFILLER_0_56_419 VGND VGND VPWR VPWR sky130_fd_sc_hd__fill_1
XFILLER_0_36_121 VGND VGND VPWR VPWR sky130_fd_sc_hd__decap_3
XFILLER_0_64_474 VGND VGND VPWR VPWR sky130_fd_sc_hd__fill_2
XFILLER_0_64_485 VPWR VGND VPWR VGND sky130_ef_sc_hd__decap_12
XFILLER_0_91_293 VPWR VGND VPWR VGND sky130_ef_sc_hd__decap_12
XFILLER_0_10_15 VPWR VGND VPWR VGND sky130_ef_sc_hd__decap_12
XFILLER_0_20_533 VGND VGND VPWR VPWR sky130_fd_sc_hd__decap_8
XFILLER_0_19_57 VPWR VGND VPWR VGND sky130_ef_sc_hd__decap_12
XFILLER_0_35_34 VGND VGND VPWR VPWR sky130_fd_sc_hd__fill_2
XFILLER_0_35_78 VGND VGND VPWR VPWR sky130_fd_sc_hd__decap_8
XFILLER_0_7_505 VPWR VGND VPWR VGND sky130_ef_sc_hd__decap_12
XFILLER_0_27_110 VGND VGND VPWR VPWR sky130_fd_sc_hd__fill_2
X_3801_ _0766_ _0778_ _0790_ _0796_ VGND VGND VPWR VPWR _0051_ sky130_fd_sc_hd__a31o_1
XFILLER_0_51_44 VPWR VGND VPWR VGND sky130_ef_sc_hd__decap_12
X_4781_ clknet_leaf_48_clock _0587_ VGND VGND VPWR VPWR fifo3.mem\[12\]\[0\] sky130_fd_sc_hd__dfxtp_1
X_3732_ fifo1.temp VGND VGND VPWR VPWR _0745_ sky130_fd_sc_hd__buf_4
XFILLER_0_42_113 VGND VGND VPWR VPWR sky130_fd_sc_hd__decap_8
XFILLER_0_55_463 VGND VGND VPWR VPWR sky130_fd_sc_hd__fill_2
X_3663_ _0692_ VGND VGND VPWR VPWR net14 sky130_fd_sc_hd__clkbuf_1
XFILLER_0_70_455 VGND VGND VPWR VPWR sky130_fd_sc_hd__fill_2
XFILLER_0_23_360 VPWR VGND VPWR VGND sky130_ef_sc_hd__decap_12
XFILLER_0_42_179 VGND VGND VPWR VPWR sky130_fd_sc_hd__fill_1
X_2614_ _0738_ _0870_ _1431_ _1441_ net207 VGND VGND VPWR VPWR _0318_ sky130_fd_sc_hd__a32o_1
XFILLER_0_70_477 VGND VGND VPWR VPWR sky130_fd_sc_hd__fill_2
XFILLER_0_23_393 VPWR VGND VPWR VGND sky130_ef_sc_hd__decap_12
X_3594_ fifo3.rd_pointer\[4\] fifo3.wr_pointer\[4\] VGND VGND VPWR VPWR _0632_ sky130_fd_sc_hd__and2b_1
X_2545_ _1419_ _1420_ _0841_ _0844_ fifo3.mem\[3\]\[1\] VGND VGND VPWR VPWR _1421_
+ sky130_fd_sc_hd__o311a_1
X_2476_ _1357_ _1358_ _1181_ VGND VGND VPWR VPWR _1359_ sky130_fd_sc_hd__o21ai_1
XFILLER_0_76_85 VGND VGND VPWR VPWR sky130_fd_sc_hd__decap_3
X_4215_ clknet_leaf_31_clock _0029_ VGND VGND VPWR VPWR fifo2.mem\[3\]\[3\] sky130_fd_sc_hd__dfxtp_1
X_4146_ _1026_ _0680_ _0656_ regis.header_byte\[6\] VGND VGND VPWR VPWR _1037_ sky130_fd_sc_hd__a31o_1
X_4077_ _0693_ VGND VGND VPWR VPWR _0983_ sky130_fd_sc_hd__buf_4
XFILLER_0_78_533 VGND VGND VPWR VPWR sky130_fd_sc_hd__decap_8
X_3028_ fifo2.mem\[12\]\[7\] fifo2.mem\[13\]\[7\] fifo2.mem\[14\]\[7\] fifo2.mem\[15\]\[7\]
+ _1669_ _1702_ VGND VGND VPWR VPWR _1729_ sky130_fd_sc_hd__mux4_2
XFILLER_0_18_165 VGND VGND VPWR VPWR sky130_fd_sc_hd__fill_1
XFILLER_0_61_411 VGND VGND VPWR VPWR sky130_fd_sc_hd__fill_1
XFILLER_0_33_113 VPWR VGND VPWR VGND sky130_ef_sc_hd__decap_12
XFILLER_0_61_466 VGND VGND VPWR VPWR sky130_fd_sc_hd__decap_6
XFILLER_0_61_488 VPWR VGND VPWR VGND sky130_ef_sc_hd__decap_12
XFILLER_0_84_525 VGND VGND VPWR VPWR sky130_fd_sc_hd__decap_6
XFILLER_0_56_238 VGND VGND VPWR VPWR sky130_fd_sc_hd__fill_2
XFILLER_0_49_290 VGND VGND VPWR VPWR sky130_fd_sc_hd__decap_6
XFILLER_0_37_485 VGND VGND VPWR VPWR sky130_fd_sc_hd__fill_1
XFILLER_0_24_113 VGND VGND VPWR VPWR sky130_fd_sc_hd__decap_3
XFILLER_0_52_433 VGND VGND VPWR VPWR sky130_fd_sc_hd__decap_6
XFILLER_0_52_477 VPWR VGND VPWR VGND sky130_ef_sc_hd__decap_12
X_2330_ _1214_ _1215_ _1217_ VGND VGND VPWR VPWR _1218_ sky130_fd_sc_hd__o21ai_1
XFILLER_0_20_396 VGND VGND VPWR VPWR sky130_fd_sc_hd__fill_2
X_2261_ _1154_ VGND VGND VPWR VPWR _0252_ sky130_fd_sc_hd__clkbuf_1
XFILLER_0_46_33 VGND VGND VPWR VPWR sky130_fd_sc_hd__fill_1
X_4000_ _0742_ VGND VGND VPWR VPWR _0936_ sky130_fd_sc_hd__buf_4
X_2192_ _1109_ _1117_ _1118_ net195 VGND VGND VPWR VPWR _0219_ sky130_fd_sc_hd__a22o_1
XFILLER_0_1_57 VPWR VGND VPWR VGND sky130_ef_sc_hd__decap_12
XFILLER_0_87_385 VGND VGND VPWR VPWR sky130_fd_sc_hd__decap_6
X_4764_ clknet_leaf_60_clock _0570_ VGND VGND VPWR VPWR fifo3.mem\[10\]\[1\] sky130_fd_sc_hd__dfxtp_1
XFILLER_0_15_113 VGND VGND VPWR VPWR sky130_fd_sc_hd__fill_2
X_3715_ _0733_ VGND VGND VPWR VPWR _0734_ sky130_fd_sc_hd__clkbuf_8
XFILLER_0_70_230 VPWR VGND VPWR VGND sky130_ef_sc_hd__decap_12
X_4695_ clknet_leaf_16_clock _0501_ VGND VGND VPWR VPWR fifo1.mem\[15\]\[5\] sky130_fd_sc_hd__dfxtp_1
X_3646_ _0660_ VGND VGND VPWR VPWR _0680_ sky130_fd_sc_hd__buf_2
XFILLER_0_30_105 VGND VGND VPWR VPWR sky130_fd_sc_hd__fill_2
XFILLER_0_70_296 VGND VGND VPWR VPWR sky130_fd_sc_hd__fill_1
XFILLER_0_87_51 VGND VGND VPWR VPWR sky130_fd_sc_hd__decap_4
XFILLER_0_30_149 VGND VGND VPWR VPWR sky130_fd_sc_hd__decap_4
X_3577_ _0611_ _0612_ _0614_ _0615_ VGND VGND VPWR VPWR _0616_ sky130_fd_sc_hd__o22a_4
XFILLER_0_60_3 VPWR VGND VPWR VGND sky130_ef_sc_hd__decap_12
XFILLER_0_11_352 VGND VGND VPWR VPWR sky130_fd_sc_hd__decap_8
X_2528_ _1406_ _0874_ _1407_ VGND VGND VPWR VPWR _1408_ sky130_fd_sc_hd__and3_1
Xhold37 fifo1.mem\[3\]\[0\] VGND VGND VPWR VPWR net85 sky130_fd_sc_hd__dlygate4sd3_1
X_2459_ _1320_ fifo1.mem\[1\]\[6\] _1342_ VGND VGND VPWR VPWR _1343_ sky130_fd_sc_hd__o21ai_1
Xhold15 fifo2.mem\[13\]\[7\] VGND VGND VPWR VPWR net63 sky130_fd_sc_hd__dlygate4sd3_1
Xhold26 fifo2.mem\[3\]\[3\] VGND VGND VPWR VPWR net74 sky130_fd_sc_hd__dlygate4sd3_1
Xhold48 fifo2.mem\[9\]\[8\] VGND VGND VPWR VPWR net96 sky130_fd_sc_hd__dlygate4sd3_1
Xhold59 fifo1.mem\[5\]\[2\] VGND VGND VPWR VPWR net107 sky130_fd_sc_hd__dlygate4sd3_1
X_4129_ _0658_ _0659_ VGND VGND VPWR VPWR _1026_ sky130_fd_sc_hd__nand2_4
XFILLER_0_78_341 VPWR VGND VPWR VGND sky130_ef_sc_hd__decap_12
XFILLER_0_38_227 VGND VGND VPWR VPWR sky130_fd_sc_hd__decap_8
XFILLER_0_19_441 VGND VGND VPWR VPWR sky130_fd_sc_hd__decap_6
XFILLER_0_81_517 VPWR VGND VPWR VGND sky130_ef_sc_hd__decap_12
XFILLER_0_69_341 VGND VGND VPWR VPWR sky130_fd_sc_hd__fill_1
XFILLER_0_29_216 VGND VGND VPWR VPWR sky130_fd_sc_hd__fill_2
XTAP_1072 VGND VPWR sky130_fd_sc_hd__tapvpwrvgnd_1
XTAP_1061 VGND VPWR sky130_fd_sc_hd__tapvpwrvgnd_1
XTAP_1050 VGND VPWR sky130_fd_sc_hd__tapvpwrvgnd_1
XFILLER_0_32_35 VGND VGND VPWR VPWR sky130_fd_sc_hd__fill_1
XFILLER_0_84_377 VGND VGND VPWR VPWR sky130_fd_sc_hd__decap_8
XFILLER_0_72_506 VGND VGND VPWR VPWR sky130_fd_sc_hd__decap_4
XFILLER_0_25_400 VPWR VGND VPWR VGND sky130_ef_sc_hd__decap_12
XFILLER_0_25_444 VGND VGND VPWR VPWR sky130_fd_sc_hd__decap_4
XFILLER_0_37_293 VGND VGND VPWR VPWR sky130_fd_sc_hd__fill_2
XFILLER_0_4_349 VPWR VGND VPWR VGND sky130_ef_sc_hd__decap_12
X_3500_ _0735_ _0746_ _0871_ _2081_ net217 VGND VGND VPWR VPWR _0563_ sky130_fd_sc_hd__a32o_1
X_4480_ clknet_leaf_37_clock _0286_ VGND VGND VPWR VPWR fifo2.mem\[14\]\[8\] sky130_fd_sc_hd__dfxtp_1
XFILLER_0_12_149 VGND VGND VPWR VPWR sky130_fd_sc_hd__fill_2
X_3431_ _2032_ _2033_ _2025_ _2034_ VGND VGND VPWR VPWR _2035_ sky130_fd_sc_hd__a211o_1
XFILLER_0_0_533 VGND VGND VPWR VPWR sky130_fd_sc_hd__decap_4
X_3362_ _1772_ _0784_ _1416_ _0634_ VGND VGND VPWR VPWR _1983_ sky130_fd_sc_hd__a31o_1
XTAP_801 VGND VPWR sky130_fd_sc_hd__tapvpwrvgnd_1
X_2313_ _1192_ _1200_ VGND VGND VPWR VPWR _1201_ sky130_fd_sc_hd__nand2_1
XTAP_812 VGND VPWR sky130_fd_sc_hd__tapvpwrvgnd_1
XTAP_823 VGND VPWR sky130_fd_sc_hd__tapvpwrvgnd_1
XTAP_834 VGND VPWR sky130_fd_sc_hd__tapvpwrvgnd_1
X_3293_ fifo3.mem\[7\]\[5\] VGND VGND VPWR VPWR _1920_ sky130_fd_sc_hd__inv_2
XFILLER_0_57_65 VGND VGND VPWR VPWR sky130_fd_sc_hd__decap_4
XTAP_845 VGND VPWR sky130_fd_sc_hd__tapvpwrvgnd_1
XTAP_856 VGND VPWR sky130_fd_sc_hd__tapvpwrvgnd_1
XTAP_867 VGND VPWR sky130_fd_sc_hd__tapvpwrvgnd_1
X_2244_ _1108_ _1141_ _1144_ net143 VGND VGND VPWR VPWR _0245_ sky130_fd_sc_hd__a22o_1
XTAP_889 VGND VPWR sky130_fd_sc_hd__tapvpwrvgnd_1
XTAP_878 VGND VPWR sky130_fd_sc_hd__tapvpwrvgnd_1
X_2175_ _1104_ _1114_ _1115_ net197 VGND VGND VPWR VPWR _0205_ sky130_fd_sc_hd__a22o_1
XFILLER_0_79_116 VPWR VGND VPWR VGND sky130_ef_sc_hd__decap_12
XFILLER_0_73_97 VGND VGND VPWR VPWR sky130_fd_sc_hd__decap_3
XFILLER_0_75_333 VGND VGND VPWR VPWR sky130_fd_sc_hd__decap_3
XFILLER_0_63_539 VGND VGND VPWR VPWR sky130_fd_sc_hd__fill_2
XFILLER_0_16_455 VGND VGND VPWR VPWR sky130_fd_sc_hd__decap_3
X_4747_ clknet_leaf_52_clock _0553_ VGND VGND VPWR VPWR fifo3.mem\[0\]\[2\] sky130_fd_sc_hd__dfxtp_1
X_4678_ clknet_leaf_61_clock _0484_ VGND VGND VPWR VPWR fifo3.mem\[4\]\[1\] sky130_fd_sc_hd__dfxtp_1
X_3629_ _0658_ _0659_ _0660_ VGND VGND VPWR VPWR _0666_ sky130_fd_sc_hd__nand3b_1
XFILLER_0_31_447 VGND VGND VPWR VPWR sky130_fd_sc_hd__fill_1
Xoutput27 net27 VGND VGND VPWR VPWR data_out_1[4] sky130_fd_sc_hd__clkbuf_4
XFILLER_0_3_393 VPWR VGND VPWR VGND sky130_ef_sc_hd__decap_12
Xoutput16 net16 VGND VGND VPWR VPWR data_out_0[1] sky130_fd_sc_hd__clkbuf_4
Xoutput38 net38 VGND VGND VPWR VPWR data_out_2[7] sky130_fd_sc_hd__buf_2
XPHY_100 VGND VGND VPWR VPWR sky130_fd_sc_hd__decap_3
XPHY_111 VGND VGND VPWR VPWR sky130_fd_sc_hd__decap_3
XPHY_122 VGND VGND VPWR VPWR sky130_fd_sc_hd__decap_3
XPHY_133 VGND VGND VPWR VPWR sky130_fd_sc_hd__decap_3
XPHY_166 VGND VGND VPWR VPWR sky130_fd_sc_hd__decap_3
XPHY_155 VGND VGND VPWR VPWR sky130_fd_sc_hd__decap_3
XPHY_144 VGND VGND VPWR VPWR sky130_fd_sc_hd__decap_3
XFILLER_0_19_260 VGND VGND VPWR VPWR sky130_fd_sc_hd__decap_4
XPHY_177 VGND VGND VPWR VPWR sky130_fd_sc_hd__decap_3
XFILLER_0_22_425 VPWR VGND VPWR VGND sky130_ef_sc_hd__decap_12
XFILLER_0_27_57 VGND VGND VPWR VPWR sky130_fd_sc_hd__decap_3
XFILLER_0_89_447 VGND VGND VPWR VPWR sky130_fd_sc_hd__fill_1
XFILLER_0_76_108 VGND VGND VPWR VPWR sky130_fd_sc_hd__fill_2
XPHY_2 VGND VGND VPWR VPWR sky130_fd_sc_hd__decap_3
X_3980_ _0776_ _0920_ _0921_ VGND VGND VPWR VPWR _0922_ sky130_fd_sc_hd__a21oi_2
XFILLER_0_84_130 VGND VGND VPWR VPWR sky130_fd_sc_hd__decap_8
X_2931_ _1556_ fifo2.mem\[14\]\[4\] _1570_ VGND VGND VPWR VPWR _1635_ sky130_fd_sc_hd__o21a_1
XFILLER_0_84_141 VGND VGND VPWR VPWR sky130_fd_sc_hd__decap_3
XFILLER_0_45_517 VPWR VGND VPWR VGND sky130_ef_sc_hd__decap_12
XFILLER_0_84_174 VGND VGND VPWR VPWR sky130_fd_sc_hd__fill_1
X_2862_ fifo2.mem\[3\]\[2\] _1567_ VGND VGND VPWR VPWR _1568_ sky130_fd_sc_hd__and2b_1
X_4601_ clknet_leaf_12_clock _0407_ VGND VGND VPWR VPWR fifo1.mem\[1\]\[3\] sky130_fd_sc_hd__dfxtp_1
XFILLER_0_72_358 VGND VGND VPWR VPWR sky130_fd_sc_hd__decap_6
X_2793_ net44 _1510_ _1169_ VGND VGND VPWR VPWR _1511_ sky130_fd_sc_hd__and3b_1
X_4532_ clknet_leaf_24_clock _0338_ VGND VGND VPWR VPWR fifo2.mem\[7\]\[6\] sky130_fd_sc_hd__dfxtp_1
XFILLER_0_40_244 VGND VGND VPWR VPWR sky130_fd_sc_hd__decap_8
X_4463_ clknet_leaf_4_clock _0269_ VGND VGND VPWR VPWR fifo3.mem\[3\]\[0\] sky130_fd_sc_hd__dfxtp_1
X_3414_ net42 net12 VGND VGND VPWR VPWR _2020_ sky130_fd_sc_hd__nand2_2
X_4394_ clknet_leaf_14_clock _0208_ VGND VGND VPWR VPWR fifo1.mem\[2\]\[5\] sky130_fd_sc_hd__dfxtp_1
XFILLER_0_0_363 VGND VGND VPWR VPWR sky130_fd_sc_hd__fill_1
X_3345_ _1832_ fifo3.mem\[8\]\[7\] _1893_ VGND VGND VPWR VPWR _1970_ sky130_fd_sc_hd__o21ba_1
XTAP_620 VGND VPWR sky130_fd_sc_hd__tapvpwrvgnd_1
XTAP_631 VGND VPWR sky130_fd_sc_hd__tapvpwrvgnd_1
XTAP_642 VGND VPWR sky130_fd_sc_hd__tapvpwrvgnd_1
X_3276_ _1812_ _1898_ _0011_ _1903_ VGND VGND VPWR VPWR _1904_ sky130_fd_sc_hd__o211ai_4
XTAP_653 VGND VPWR sky130_fd_sc_hd__tapvpwrvgnd_1
XTAP_664 VGND VPWR sky130_fd_sc_hd__tapvpwrvgnd_1
XTAP_675 VGND VPWR sky130_fd_sc_hd__tapvpwrvgnd_1
XTAP_686 VGND VPWR sky130_fd_sc_hd__tapvpwrvgnd_1
X_2227_ net339 _1137_ _1139_ _0930_ VGND VGND VPWR VPWR _0233_ sky130_fd_sc_hd__a22o_1
XTAP_697 VGND VPWR sky130_fd_sc_hd__tapvpwrvgnd_1
XFILLER_0_23_3 VPWR VGND VPWR VGND sky130_ef_sc_hd__decap_12
X_2158_ _0737_ VGND VGND VPWR VPWR _1106_ sky130_fd_sc_hd__clkbuf_4
XFILLER_0_63_303 VGND VGND VPWR VPWR sky130_fd_sc_hd__fill_1
XFILLER_0_75_196 VGND VGND VPWR VPWR sky130_fd_sc_hd__fill_2
XFILLER_0_90_133 VGND VGND VPWR VPWR sky130_fd_sc_hd__decap_6
XFILLER_0_90_177 VPWR VGND VPWR VGND sky130_ef_sc_hd__decap_12
XFILLER_0_31_299 VGND VGND VPWR VPWR sky130_fd_sc_hd__decap_8
XFILLER_0_13_15 VPWR VGND VPWR VGND sky130_ef_sc_hd__decap_12
XFILLER_0_27_517 VGND VGND VPWR VPWR sky130_fd_sc_hd__decap_6
XFILLER_0_27_539 VGND VGND VPWR VPWR sky130_fd_sc_hd__fill_2
XFILLER_0_81_166 VGND VGND VPWR VPWR sky130_fd_sc_hd__fill_2
XFILLER_0_50_520 VPWR VGND VPWR VGND sky130_ef_sc_hd__decap_12
XFILLER_0_22_277 VPWR VGND VPWR VGND sky130_ef_sc_hd__decap_12
X_3130_ _0926_ _1789_ _1791_ VGND VGND VPWR VPWR _0484_ sky130_fd_sc_hd__o21a_1
X_3061_ net187 _1749_ _1751_ _0797_ VGND VGND VPWR VPWR _0455_ sky130_fd_sc_hd__a22o_1
XFILLER_0_85_461 VPWR VGND VPWR VGND sky130_ef_sc_hd__decap_12
X_3963_ _0658_ regis.fifo_full_state\[1\] _0910_ VGND VGND VPWR VPWR _0912_ sky130_fd_sc_hd__mux2_1
XFILLER_0_57_152 VGND VGND VPWR VPWR sky130_fd_sc_hd__fill_1
X_2914_ _1593_ _1618_ _0981_ VGND VGND VPWR VPWR _0441_ sky130_fd_sc_hd__o21a_1
XFILLER_0_72_100 VPWR VGND VPWR VGND sky130_ef_sc_hd__decap_12
X_3894_ _0855_ _0856_ fifo2.mem\[8\]\[4\] _0857_ _0865_ VGND VGND VPWR VPWR _0075_
+ sky130_fd_sc_hd__a32o_1
X_2845_ fifo2.mem\[12\]\[8\] fifo2.mem\[13\]\[8\] fifo2.mem\[14\]\[8\] fifo2.mem\[15\]\[8\]
+ _1550_ _1540_ VGND VGND VPWR VPWR _1551_ sky130_fd_sc_hd__mux4_2
Xhold101 fifo1.mem\[3\]\[7\] VGND VGND VPWR VPWR net149 sky130_fd_sc_hd__dlygate4sd3_1
X_4515_ clknet_leaf_40_clock _0321_ VGND VGND VPWR VPWR fifo2.mem\[9\]\[7\] sky130_fd_sc_hd__dfxtp_1
X_2776_ _0961_ _0746_ _0853_ _0974_ VGND VGND VPWR VPWR _1498_ sky130_fd_sc_hd__a31o_1
Xhold112 fifo1.mem\[13\]\[2\] VGND VGND VPWR VPWR net160 sky130_fd_sc_hd__dlygate4sd3_1
Xhold134 fifo2.mem\[9\]\[0\] VGND VGND VPWR VPWR net182 sky130_fd_sc_hd__dlygate4sd3_1
Xhold123 fifo1.mem\[11\]\[8\] VGND VGND VPWR VPWR net171 sky130_fd_sc_hd__dlygate4sd3_1
Xhold145 fifo2.mem\[0\]\[0\] VGND VGND VPWR VPWR net193 sky130_fd_sc_hd__dlygate4sd3_1
Xhold156 fifo1.mem\[9\]\[8\] VGND VGND VPWR VPWR net204 sky130_fd_sc_hd__dlygate4sd3_1
Xhold167 fifo1.mem\[6\]\[8\] VGND VGND VPWR VPWR net215 sky130_fd_sc_hd__dlygate4sd3_1
X_4446_ clknet_leaf_20_clock _0252_ VGND VGND VPWR VPWR fifo1.wr_pointer\[4\] sky130_fd_sc_hd__dfxtp_2
Xhold189 fifo2.mem\[6\]\[6\] VGND VGND VPWR VPWR net237 sky130_fd_sc_hd__dlygate4sd3_1
Xhold178 fifo2.mem\[12\]\[7\] VGND VGND VPWR VPWR net226 sky130_fd_sc_hd__dlygate4sd3_1
X_4377_ clknet_leaf_8_clock _0191_ VGND VGND VPWR VPWR fifo1.mem\[9\]\[6\] sky130_fd_sc_hd__dfxtp_1
XFILLER_0_0_193 VGND VGND VPWR VPWR sky130_fd_sc_hd__decap_3
X_3328_ _1846_ fifo3.mem\[4\]\[6\] _1857_ VGND VGND VPWR VPWR _1954_ sky130_fd_sc_hd__o21ba_1
XTAP_450 VGND VPWR sky130_fd_sc_hd__tapvpwrvgnd_1
XTAP_461 VGND VPWR sky130_fd_sc_hd__tapvpwrvgnd_1
XTAP_472 VGND VPWR sky130_fd_sc_hd__tapvpwrvgnd_1
XTAP_483 VGND VPWR sky130_fd_sc_hd__tapvpwrvgnd_1
XTAP_494 VGND VPWR sky130_fd_sc_hd__tapvpwrvgnd_1
X_3259_ _1846_ fifo3.mem\[12\]\[3\] _1835_ VGND VGND VPWR VPWR _1888_ sky130_fd_sc_hd__o21bai_1
XFILLER_0_48_141 VGND VGND VPWR VPWR sky130_fd_sc_hd__decap_3
XFILLER_0_91_497 VGND VGND VPWR VPWR sky130_fd_sc_hd__decap_6
XFILLER_0_32_531 VGND VGND VPWR VPWR sky130_fd_sc_hd__fill_1
Xclkbuf_leaf_60_clock clknet_3_0__leaf_clock VGND VGND VPWR VPWR clknet_leaf_60_clock
+ sky130_fd_sc_hd__clkbuf_16
XFILLER_0_86_236 VPWR VGND VPWR VGND sky130_ef_sc_hd__decap_12
XFILLER_0_54_100 VGND VGND VPWR VPWR sky130_fd_sc_hd__fill_2
XFILLER_0_42_317 VGND VGND VPWR VPWR sky130_fd_sc_hd__fill_1
X_2630_ net297 _0963_ _1442_ _1444_ _0745_ VGND VGND VPWR VPWR _0331_ sky130_fd_sc_hd__a32o_1
XFILLER_0_35_391 VGND VGND VPWR VPWR sky130_fd_sc_hd__fill_1
X_2561_ _1428_ VGND VGND VPWR VPWR _1429_ sky130_fd_sc_hd__clkbuf_4
Xclkbuf_leaf_13_clock clknet_3_2__leaf_clock VGND VGND VPWR VPWR clknet_leaf_13_clock
+ sky130_fd_sc_hd__clkbuf_16
X_4300_ clknet_leaf_61_clock _0114_ VGND VGND VPWR VPWR fifo3.mem\[6\]\[0\] sky130_fd_sc_hd__dfxtp_1
X_2492_ _1295_ fifo1.mem\[10\]\[7\] VGND VGND VPWR VPWR _1375_ sky130_fd_sc_hd__nor2_1
X_4231_ clknet_leaf_1_clock _0045_ VGND VGND VPWR VPWR fifo3.mem\[7\]\[1\] sky130_fd_sc_hd__dfxtp_1
X_4162_ regis.internal_parity\[2\] _1046_ _1047_ VGND VGND VPWR VPWR _0161_ sky130_fd_sc_hd__o21a_1
Xclkbuf_leaf_28_clock clknet_3_7__leaf_clock VGND VGND VPWR VPWR clknet_leaf_28_clock
+ sky130_fd_sc_hd__clkbuf_16
X_3113_ _1773_ VGND VGND VPWR VPWR _1781_ sky130_fd_sc_hd__buf_2
X_4093_ regis.fifo_full_state\[1\] _0990_ _0690_ VGND VGND VPWR VPWR _0997_ sky130_fd_sc_hd__o21ba_1
X_3044_ net41 _1743_ net11 VGND VGND VPWR VPWR _1744_ sky130_fd_sc_hd__nand3_1
XFILLER_0_77_203 VPWR VGND VPWR VGND sky130_ef_sc_hd__decap_12
XFILLER_0_58_461 VGND VGND VPWR VPWR sky130_fd_sc_hd__decap_4
X_3946_ _0898_ _0899_ _0900_ VGND VGND VPWR VPWR _0901_ sky130_fd_sc_hd__and3_1
XFILLER_0_58_472 VGND VGND VPWR VPWR sky130_fd_sc_hd__decap_4
X_3877_ _0624_ _0625_ _0626_ _0627_ _0852_ VGND VGND VPWR VPWR _0853_ sky130_fd_sc_hd__a41oi_4
X_2828_ _1200_ _1379_ _1384_ _1181_ VGND VGND VPWR VPWR _1535_ sky130_fd_sc_hd__o211ai_1
X_2759_ _0745_ _1491_ _1492_ net140 VGND VGND VPWR VPWR _0412_ sky130_fd_sc_hd__a22o_1
XFILLER_0_41_361 VGND VGND VPWR VPWR sky130_fd_sc_hd__decap_4
X_4429_ clknet_leaf_50_clock _0018_ VGND VGND VPWR VPWR fsm1.present_state\[4\] sky130_fd_sc_hd__dfxtp_1
XTAP_291 VGND VPWR sky130_fd_sc_hd__tapvpwrvgnd_1
XTAP_280 VGND VPWR sky130_fd_sc_hd__tapvpwrvgnd_1
XFILLER_0_24_306 VGND VGND VPWR VPWR sky130_fd_sc_hd__fill_2
XFILLER_0_36_166 VGND VGND VPWR VPWR sky130_fd_sc_hd__fill_1
XFILLER_0_10_27 VGND VGND VPWR VPWR sky130_fd_sc_hd__fill_1
XFILLER_0_64_497 VPWR VGND VPWR VGND sky130_ef_sc_hd__decap_12
XFILLER_0_51_169 VGND VGND VPWR VPWR sky130_fd_sc_hd__decap_3
XFILLER_0_32_394 VGND VGND VPWR VPWR sky130_fd_sc_hd__decap_3
XFILLER_0_19_69 VGND VGND VPWR VPWR sky130_fd_sc_hd__fill_1
XFILLER_0_59_225 VPWR VGND VPWR VGND sky130_ef_sc_hd__decap_12
XFILLER_0_51_12 VGND VGND VPWR VPWR sky130_fd_sc_hd__fill_2
X_4780_ clknet_leaf_58_clock _0586_ VGND VGND VPWR VPWR fifo3.mem\[11\]\[8\] sky130_fd_sc_hd__dfxtp_1
X_3800_ _0785_ _0789_ fifo3.mem\[7\]\[7\] VGND VGND VPWR VPWR _0796_ sky130_fd_sc_hd__and3_1
XFILLER_0_55_420 VGND VGND VPWR VPWR sky130_fd_sc_hd__fill_1
X_3731_ _0744_ _0715_ _0741_ _0730_ net78 VGND VGND VPWR VPWR _0033_ sky130_fd_sc_hd__a32o_1
XFILLER_0_7_517 VPWR VGND VPWR VGND sky130_ef_sc_hd__decap_12
X_3662_ fsm1.present_state\[4\] fsm1.full_state _0690_ _0691_ VGND VGND VPWR VPWR
+ _0692_ sky130_fd_sc_hd__or4_4
X_3593_ fifo3.wr_pointer\[4\] fifo3.rd_pointer\[4\] VGND VGND VPWR VPWR _0631_ sky130_fd_sc_hd__and2b_1
XFILLER_0_30_309 VPWR VGND VPWR VGND sky130_ef_sc_hd__decap_12
X_2613_ _0736_ _0870_ _1431_ _1441_ net202 VGND VGND VPWR VPWR _0317_ sky130_fd_sc_hd__a32o_1
XFILLER_0_11_501 VGND VGND VPWR VPWR sky130_fd_sc_hd__decap_3
XFILLER_0_23_372 VPWR VGND VPWR VGND sky130_ef_sc_hd__decap_12
X_2544_ _1417_ VGND VGND VPWR VPWR _1420_ sky130_fd_sc_hd__clkbuf_4
X_2475_ _1319_ _1322_ _1187_ VGND VGND VPWR VPWR _1358_ sky130_fd_sc_hd__o21a_1
XFILLER_0_76_75 VGND VGND VPWR VPWR sky130_fd_sc_hd__fill_1
X_4214_ clknet_leaf_31_clock _0028_ VGND VGND VPWR VPWR fifo2.mem\[3\]\[2\] sky130_fd_sc_hd__dfxtp_1
X_4145_ net6 _1027_ _1035_ _1036_ VGND VGND VPWR VPWR _0155_ sky130_fd_sc_hd__o211a_1
XFILLER_0_78_501 VPWR VGND VPWR VGND sky130_ef_sc_hd__decap_12
X_4076_ _0745_ _0723_ _0869_ _0975_ net65 VGND VGND VPWR VPWR _0140_ sky130_fd_sc_hd__a32o_1
X_3027_ _1547_ _1727_ VGND VGND VPWR VPWR _1728_ sky130_fd_sc_hd__nand2_1
XFILLER_0_65_228 VPWR VGND VPWR VGND sky130_ef_sc_hd__decap_12
X_3929_ syn.count1\[3\] syn.count1\[4\] _0884_ VGND VGND VPWR VPWR _0889_ sky130_fd_sc_hd__nand3_1
XFILLER_0_33_125 VGND VGND VPWR VPWR sky130_fd_sc_hd__decap_4
XFILLER_0_33_136 VPWR VGND VPWR VGND sky130_ef_sc_hd__decap_12
XFILLER_0_33_169 VGND VGND VPWR VPWR sky130_fd_sc_hd__decap_4
XFILLER_0_14_394 VGND VGND VPWR VPWR sky130_fd_sc_hd__fill_1
XFILLER_0_88_309 VPWR VGND VPWR VGND sky130_ef_sc_hd__decap_12
XFILLER_0_21_15 VPWR VGND VPWR VGND sky130_ef_sc_hd__decap_12
XFILLER_0_21_48 VGND VGND VPWR VPWR sky130_fd_sc_hd__decap_8
XFILLER_0_12_309 VGND VGND VPWR VPWR sky130_fd_sc_hd__decap_6
X_2260_ _1152_ _1153_ fifo1.wr_pointer\[4\] VGND VGND VPWR VPWR _1154_ sky130_fd_sc_hd__mux2_1
XFILLER_0_46_56 VGND VGND VPWR VPWR sky130_fd_sc_hd__decap_3
X_2191_ _1108_ _1117_ _1118_ net245 VGND VGND VPWR VPWR _0218_ sky130_fd_sc_hd__a22o_1
XFILLER_0_79_309 VPWR VGND VPWR VGND sky130_ef_sc_hd__decap_12
XFILLER_0_1_69 VGND VGND VPWR VPWR sky130_fd_sc_hd__decap_8
X_4763_ clknet_leaf_60_clock _0569_ VGND VGND VPWR VPWR fifo3.mem\[10\]\[0\] sky130_fd_sc_hd__dfxtp_1
X_3714_ fifo1.data_in\[2\] VGND VGND VPWR VPWR _0733_ sky130_fd_sc_hd__buf_4
XFILLER_0_55_272 VGND VGND VPWR VPWR sky130_fd_sc_hd__decap_8
X_4694_ clknet_leaf_18_clock _0500_ VGND VGND VPWR VPWR fifo1.mem\[15\]\[4\] sky130_fd_sc_hd__dfxtp_1
XFILLER_0_15_158 VGND VGND VPWR VPWR sky130_fd_sc_hd__fill_1
XFILLER_0_70_242 VGND VGND VPWR VPWR sky130_fd_sc_hd__decap_8
XFILLER_0_70_253 VPWR VGND VPWR VGND sky130_ef_sc_hd__decap_12
X_3645_ fsm1.parity_done _0677_ _0678_ VGND VGND VPWR VPWR _0679_ sky130_fd_sc_hd__o21ai_1
XFILLER_0_30_117 VGND VGND VPWR VPWR sky130_fd_sc_hd__decap_3
X_3576_ fifo1.rd_pointer\[3\] fifo1.wr_pointer\[3\] VGND VGND VPWR VPWR _0615_ sky130_fd_sc_hd__and2_1
X_2527_ net42 _1402_ _0637_ net12 fifo3.rd_pointer\[1\] VGND VGND VPWR VPWR _1407_
+ sky130_fd_sc_hd__a41o_1
X_2458_ _1295_ fifo1.mem\[0\]\[6\] _1183_ VGND VGND VPWR VPWR _1342_ sky130_fd_sc_hd__o21ba_1
XFILLER_0_53_3 VGND VGND VPWR VPWR sky130_fd_sc_hd__decap_8
Xhold38 fifo2.mem\[3\]\[1\] VGND VGND VPWR VPWR net86 sky130_fd_sc_hd__dlygate4sd3_1
Xhold16 fifo3.mem\[13\]\[4\] VGND VGND VPWR VPWR net64 sky130_fd_sc_hd__dlygate4sd3_1
Xhold27 fifo2.mem\[11\]\[7\] VGND VGND VPWR VPWR net75 sky130_fd_sc_hd__dlygate4sd3_1
Xhold49 fifo3.mem\[15\]\[1\] VGND VGND VPWR VPWR net97 sky130_fd_sc_hd__dlygate4sd3_1
X_2389_ _1272_ _1274_ _1185_ VGND VGND VPWR VPWR _1275_ sky130_fd_sc_hd__a21o_1
X_4128_ _1023_ _1025_ _1005_ VGND VGND VPWR VPWR _0149_ sky130_fd_sc_hd__a21boi_1
X_4059_ _0973_ VGND VGND VPWR VPWR _0974_ sky130_fd_sc_hd__buf_6
XFILLER_0_78_353 VGND VGND VPWR VPWR sky130_fd_sc_hd__decap_8
XFILLER_0_78_397 VGND VGND VPWR VPWR sky130_fd_sc_hd__decap_6
XFILLER_0_81_529 VGND VGND VPWR VPWR sky130_fd_sc_hd__decap_8
XFILLER_0_21_117 VGND VGND VPWR VPWR sky130_fd_sc_hd__fill_1
XTAP_1040 VGND VPWR sky130_fd_sc_hd__tapvpwrvgnd_1
XTAP_1073 VGND VPWR sky130_fd_sc_hd__tapvpwrvgnd_1
XTAP_1062 VGND VPWR sky130_fd_sc_hd__tapvpwrvgnd_1
XTAP_1051 VGND VPWR sky130_fd_sc_hd__tapvpwrvgnd_1
XFILLER_0_32_69 VPWR VGND VPWR VGND sky130_ef_sc_hd__decap_12
XFILLER_0_44_209 VGND VGND VPWR VPWR sky130_fd_sc_hd__decap_4
XFILLER_0_4_306 VGND VGND VPWR VPWR sky130_fd_sc_hd__fill_2
XFILLER_0_52_220 VGND VGND VPWR VPWR sky130_fd_sc_hd__decap_8
XFILLER_0_25_467 VGND VGND VPWR VPWR sky130_fd_sc_hd__fill_2
XFILLER_0_40_415 VGND VGND VPWR VPWR sky130_fd_sc_hd__decap_4
XFILLER_0_12_128 VPWR VGND VPWR VGND sky130_ef_sc_hd__decap_12
XFILLER_0_0_501 VGND VGND VPWR VPWR sky130_fd_sc_hd__decap_3
X_3430_ _2033_ _2032_ VGND VGND VPWR VPWR _2034_ sky130_fd_sc_hd__nor2_1
X_3361_ _1982_ VGND VGND VPWR VPWR _0524_ sky130_fd_sc_hd__clkbuf_1
X_2312_ _0002_ VGND VGND VPWR VPWR _1200_ sky130_fd_sc_hd__clkbuf_4
XTAP_802 VGND VPWR sky130_fd_sc_hd__tapvpwrvgnd_1
XTAP_813 VGND VPWR sky130_fd_sc_hd__tapvpwrvgnd_1
XTAP_824 VGND VPWR sky130_fd_sc_hd__tapvpwrvgnd_1
XTAP_835 VGND VPWR sky130_fd_sc_hd__tapvpwrvgnd_1
X_3292_ _1917_ _1864_ _1918_ VGND VGND VPWR VPWR _1919_ sky130_fd_sc_hd__a21oi_1
XTAP_846 VGND VPWR sky130_fd_sc_hd__tapvpwrvgnd_1
XTAP_857 VGND VPWR sky130_fd_sc_hd__tapvpwrvgnd_1
XTAP_868 VGND VPWR sky130_fd_sc_hd__tapvpwrvgnd_1
X_2243_ _1107_ _1141_ _1144_ net312 VGND VGND VPWR VPWR _0244_ sky130_fd_sc_hd__a22o_1
XTAP_879 VGND VPWR sky130_fd_sc_hd__tapvpwrvgnd_1
X_2174_ _1098_ _1114_ _1115_ net118 VGND VGND VPWR VPWR _0204_ sky130_fd_sc_hd__a22o_1
XFILLER_0_79_106 VGND VGND VPWR VPWR sky130_fd_sc_hd__decap_6
XFILLER_0_79_128 VGND VGND VPWR VPWR sky130_fd_sc_hd__fill_2
XFILLER_0_73_65 VGND VGND VPWR VPWR sky130_fd_sc_hd__fill_1
XFILLER_0_7_111 VGND VGND VPWR VPWR sky130_fd_sc_hd__fill_1
XFILLER_0_28_250 VGND VGND VPWR VPWR sky130_fd_sc_hd__fill_2
XFILLER_0_63_518 VGND VGND VPWR VPWR sky130_fd_sc_hd__decap_4
XFILLER_0_28_272 VPWR VGND VPWR VGND sky130_ef_sc_hd__decap_12
X_4746_ clknet_leaf_3_clock _0552_ VGND VGND VPWR VPWR fifo3.mem\[0\]\[1\] sky130_fd_sc_hd__dfxtp_1
X_4677_ clknet_leaf_61_clock _0483_ VGND VGND VPWR VPWR fifo3.mem\[4\]\[0\] sky130_fd_sc_hd__dfxtp_1
XFILLER_0_31_404 VGND VGND VPWR VPWR sky130_fd_sc_hd__decap_4
XFILLER_0_3_361 VPWR VGND VPWR VGND sky130_ef_sc_hd__decap_12
X_3628_ net40 _0657_ _0661_ net41 _0664_ VGND VGND VPWR VPWR _0665_ sky130_fd_sc_hd__a221oi_2
Xoutput17 net17 VGND VGND VPWR VPWR data_out_0[2] sky130_fd_sc_hd__clkbuf_4
Xoutput28 net28 VGND VGND VPWR VPWR data_out_1[5] sky130_fd_sc_hd__clkbuf_4
Xoutput39 net39 VGND VGND VPWR VPWR error sky130_fd_sc_hd__clkbuf_4
X_3559_ _0733_ _1753_ _0920_ _2106_ net222 VGND VGND VPWR VPWR _0598_ sky130_fd_sc_hd__a32o_1
XFILLER_0_66_301 VGND VGND VPWR VPWR sky130_fd_sc_hd__decap_6
XFILLER_0_78_194 VGND VGND VPWR VPWR sky130_fd_sc_hd__fill_2
XPHY_101 VGND VGND VPWR VPWR sky130_fd_sc_hd__decap_3
XPHY_112 VGND VGND VPWR VPWR sky130_fd_sc_hd__decap_3
XPHY_123 VGND VGND VPWR VPWR sky130_fd_sc_hd__decap_3
XPHY_134 VGND VGND VPWR VPWR sky130_fd_sc_hd__decap_3
XPHY_167 VGND VGND VPWR VPWR sky130_fd_sc_hd__decap_3
XPHY_156 VGND VGND VPWR VPWR sky130_fd_sc_hd__decap_3
XPHY_145 VGND VGND VPWR VPWR sky130_fd_sc_hd__decap_3
XFILLER_0_26_209 VGND VGND VPWR VPWR sky130_fd_sc_hd__decap_6
XPHY_178 VGND VGND VPWR VPWR sky130_fd_sc_hd__decap_3
XFILLER_0_81_337 VPWR VGND VPWR VGND sky130_ef_sc_hd__decap_12
XFILLER_0_19_294 VGND VGND VPWR VPWR sky130_fd_sc_hd__fill_1
XFILLER_0_34_253 VPWR VGND VPWR VGND sky130_ef_sc_hd__decap_12
XFILLER_0_22_437 VGND VGND VPWR VPWR sky130_fd_sc_hd__fill_2
XPHY_3 VGND VGND VPWR VPWR sky130_fd_sc_hd__decap_3
XFILLER_0_43_57 VPWR VGND VPWR VGND sky130_ef_sc_hd__decap_12
X_2930_ _1572_ fifo2.mem\[13\]\[4\] _1633_ VGND VGND VPWR VPWR _1634_ sky130_fd_sc_hd__o21ai_1
X_4600_ clknet_leaf_12_clock _0406_ VGND VGND VPWR VPWR fifo1.mem\[1\]\[2\] sky130_fd_sc_hd__dfxtp_1
XFILLER_0_45_529 VPWR VGND VPWR VGND sky130_ef_sc_hd__decap_12
X_2861_ _0004_ VGND VGND VPWR VPWR _1567_ sky130_fd_sc_hd__clkbuf_4
XFILLER_0_25_242 VGND VGND VPWR VPWR sky130_fd_sc_hd__decap_3
X_2792_ fifo2.rd_pointer\[0\] _1504_ fifo2.rd_pointer\[1\] VGND VGND VPWR VPWR _1510_
+ sky130_fd_sc_hd__a21o_1
XFILLER_0_40_201 VGND VGND VPWR VPWR sky130_fd_sc_hd__fill_1
X_4531_ clknet_leaf_22_clock _0337_ VGND VGND VPWR VPWR fifo2.mem\[7\]\[5\] sky130_fd_sc_hd__dfxtp_1
X_4462_ clknet_leaf_49_clock _0268_ VGND VGND VPWR VPWR _0011_ sky130_fd_sc_hd__dfxtp_4
XFILLER_0_40_223 VPWR VGND VPWR VGND sky130_ef_sc_hd__decap_12
XFILLER_0_7_57 VPWR VGND VPWR VGND sky130_ef_sc_hd__decap_12
X_3413_ _2009_ _2011_ _1814_ _2018_ VGND VGND VPWR VPWR _2019_ sky130_fd_sc_hd__o2bb2a_2
XFILLER_0_40_278 VGND VGND VPWR VPWR sky130_fd_sc_hd__fill_1
XFILLER_0_21_481 VGND VGND VPWR VPWR sky130_fd_sc_hd__decap_4
X_4393_ clknet_leaf_11_clock _0207_ VGND VGND VPWR VPWR fifo1.mem\[2\]\[4\] sky130_fd_sc_hd__dfxtp_1
X_3344_ fifo3.mem\[12\]\[7\] fifo3.mem\[13\]\[7\] fifo3.mem\[14\]\[7\] fifo3.mem\[15\]\[7\]
+ _1864_ _1807_ VGND VGND VPWR VPWR _1969_ sky130_fd_sc_hd__mux4_1
XTAP_610 VGND VPWR sky130_fd_sc_hd__tapvpwrvgnd_1
XTAP_621 VGND VPWR sky130_fd_sc_hd__tapvpwrvgnd_1
XTAP_632 VGND VPWR sky130_fd_sc_hd__tapvpwrvgnd_1
XTAP_643 VGND VPWR sky130_fd_sc_hd__tapvpwrvgnd_1
X_3275_ _1900_ _1902_ _0010_ VGND VGND VPWR VPWR _1903_ sky130_fd_sc_hd__a21o_1
XTAP_654 VGND VPWR sky130_fd_sc_hd__tapvpwrvgnd_1
XTAP_665 VGND VPWR sky130_fd_sc_hd__tapvpwrvgnd_1
XTAP_676 VGND VPWR sky130_fd_sc_hd__tapvpwrvgnd_1
X_2226_ fifo1.mem\[6\]\[2\] _1137_ _1139_ _0927_ VGND VGND VPWR VPWR _0232_ sky130_fd_sc_hd__a22o_1
XTAP_687 VGND VPWR sky130_fd_sc_hd__tapvpwrvgnd_1
XTAP_698 VGND VPWR sky130_fd_sc_hd__tapvpwrvgnd_1
XFILLER_0_16_3 VGND VGND VPWR VPWR sky130_fd_sc_hd__fill_1
X_2157_ _1105_ _1101_ _1103_ net192 VGND VGND VPWR VPWR _0197_ sky130_fd_sc_hd__a22o_1
XFILLER_0_8_453 VGND VGND VPWR VPWR sky130_fd_sc_hd__fill_1
XFILLER_0_63_337 VGND VGND VPWR VPWR sky130_fd_sc_hd__decap_4
XFILLER_0_8_497 VPWR VGND VPWR VGND sky130_ef_sc_hd__decap_12
XFILLER_0_90_189 VGND VGND VPWR VPWR sky130_fd_sc_hd__decap_6
X_4729_ clknet_leaf_17_clock _0535_ VGND VGND VPWR VPWR net26 sky130_fd_sc_hd__dfxtp_1
XFILLER_0_71_381 VGND VGND VPWR VPWR sky130_fd_sc_hd__fill_1
XFILLER_0_13_27 VGND VGND VPWR VPWR sky130_fd_sc_hd__fill_2
XFILLER_0_39_389 VGND VGND VPWR VPWR sky130_fd_sc_hd__decap_3
XFILLER_0_66_175 VGND VGND VPWR VPWR sky130_fd_sc_hd__decap_8
XFILLER_0_66_197 VGND VGND VPWR VPWR sky130_fd_sc_hd__decap_6
XFILLER_0_22_289 VGND VGND VPWR VPWR sky130_fd_sc_hd__decap_8
X_3060_ net249 _1749_ _1751_ _0938_ VGND VGND VPWR VPWR _0454_ sky130_fd_sc_hd__a22o_1
XFILLER_0_89_278 VGND VGND VPWR VPWR sky130_fd_sc_hd__fill_2
Xclkbuf_3_5__f_clock clknet_0_clock VGND VGND VPWR VPWR clknet_3_5__leaf_clock sky130_fd_sc_hd__clkbuf_16
XFILLER_0_54_67 VGND VGND VPWR VPWR sky130_fd_sc_hd__fill_1
X_3962_ _0911_ VGND VGND VPWR VPWR _0097_ sky130_fd_sc_hd__clkbuf_1
XFILLER_0_85_473 VPWR VGND VPWR VGND sky130_ef_sc_hd__decap_12
X_2913_ _1588_ _1616_ _1617_ _1554_ VGND VGND VPWR VPWR _1618_ sky130_fd_sc_hd__o211a_1
XFILLER_0_72_112 VPWR VGND VPWR VGND sky130_ef_sc_hd__decap_12
X_3893_ _0725_ _0858_ fifo1.data_in\[4\] _0860_ VGND VGND VPWR VPWR _0865_ sky130_fd_sc_hd__and4b_1
XFILLER_0_45_337 VGND VGND VPWR VPWR sky130_fd_sc_hd__fill_1
XFILLER_0_72_156 VGND VGND VPWR VPWR sky130_fd_sc_hd__fill_1
X_2844_ _0004_ VGND VGND VPWR VPWR _1550_ sky130_fd_sc_hd__clkbuf_4
XFILLER_0_72_189 VGND VGND VPWR VPWR sky130_fd_sc_hd__decap_6
X_4514_ clknet_leaf_40_clock _0320_ VGND VGND VPWR VPWR fifo2.mem\[9\]\[6\] sky130_fd_sc_hd__dfxtp_1
X_2775_ _1447_ _1448_ _0981_ _1497_ VGND VGND VPWR VPWR _0423_ sky130_fd_sc_hd__o211a_1
Xhold102 fifo1.mem\[1\]\[1\] VGND VGND VPWR VPWR net150 sky130_fd_sc_hd__dlygate4sd3_1
Xhold135 fifo1.mem\[0\]\[1\] VGND VGND VPWR VPWR net183 sky130_fd_sc_hd__dlygate4sd3_1
Xhold124 fifo2.mem\[14\]\[1\] VGND VGND VPWR VPWR net172 sky130_fd_sc_hd__dlygate4sd3_1
Xhold113 fifo2.mem\[14\]\[4\] VGND VGND VPWR VPWR net161 sky130_fd_sc_hd__dlygate4sd3_1
Xhold146 fifo1.mem\[2\]\[7\] VGND VGND VPWR VPWR net194 sky130_fd_sc_hd__dlygate4sd3_1
Xhold168 fifo1.mem\[15\]\[7\] VGND VGND VPWR VPWR net216 sky130_fd_sc_hd__dlygate4sd3_1
Xhold157 fifo1.mem\[8\]\[1\] VGND VGND VPWR VPWR net205 sky130_fd_sc_hd__dlygate4sd3_1
X_4445_ clknet_leaf_20_clock _0251_ VGND VGND VPWR VPWR fifo1.wr_pointer\[3\] sky130_fd_sc_hd__dfxtp_1
X_4376_ clknet_leaf_2_clock _0190_ VGND VGND VPWR VPWR fifo1.mem\[9\]\[5\] sky130_fd_sc_hd__dfxtp_1
Xhold179 fifo2.mem\[4\]\[2\] VGND VGND VPWR VPWR net227 sky130_fd_sc_hd__dlygate4sd3_1
X_3327_ _1812_ _1952_ _1814_ VGND VGND VPWR VPWR _1953_ sky130_fd_sc_hd__o21ai_2
XTAP_440 VGND VPWR sky130_fd_sc_hd__tapvpwrvgnd_1
XTAP_451 VGND VPWR sky130_fd_sc_hd__tapvpwrvgnd_1
XTAP_462 VGND VPWR sky130_fd_sc_hd__tapvpwrvgnd_1
XTAP_473 VGND VPWR sky130_fd_sc_hd__tapvpwrvgnd_1
XTAP_484 VGND VPWR sky130_fd_sc_hd__tapvpwrvgnd_1
X_3258_ fifo3.mem\[13\]\[3\] VGND VGND VPWR VPWR _1887_ sky130_fd_sc_hd__inv_2
XTAP_495 VGND VPWR sky130_fd_sc_hd__tapvpwrvgnd_1
X_3189_ fifo3.mem\[4\]\[1\] fifo3.mem\[5\]\[1\] fifo3.mem\[6\]\[1\] fifo3.mem\[7\]\[1\]
+ _1805_ _1807_ VGND VGND VPWR VPWR _1820_ sky130_fd_sc_hd__mux4_1
X_2209_ _0761_ _1121_ _1125_ _1130_ VGND VGND VPWR VPWR _0224_ sky130_fd_sc_hd__a31o_1
XFILLER_0_68_429 VGND VGND VPWR VPWR sky130_fd_sc_hd__fill_2
XFILLER_0_91_421 VGND VGND VPWR VPWR sky130_fd_sc_hd__decap_8
XFILLER_0_63_101 VGND VGND VPWR VPWR sky130_fd_sc_hd__decap_8
XFILLER_0_8_261 VGND VGND VPWR VPWR sky130_fd_sc_hd__fill_2
XFILLER_0_8_283 VGND VGND VPWR VPWR sky130_fd_sc_hd__fill_1
XFILLER_0_51_307 VGND VGND VPWR VPWR sky130_fd_sc_hd__decap_3
Xclkbuf_leaf_9_clock clknet_3_2__leaf_clock VGND VGND VPWR VPWR clknet_leaf_9_clock
+ sky130_fd_sc_hd__clkbuf_16
XFILLER_0_86_248 VGND VGND VPWR VPWR sky130_fd_sc_hd__decap_4
XFILLER_0_24_37 VGND VGND VPWR VPWR sky130_fd_sc_hd__decap_8
XFILLER_0_39_142 VGND VGND VPWR VPWR sky130_fd_sc_hd__decap_8
XFILLER_0_82_421 VPWR VGND VPWR VGND sky130_ef_sc_hd__decap_12
XFILLER_0_6_209 VGND VGND VPWR VPWR sky130_fd_sc_hd__fill_2
XFILLER_0_27_337 VGND VGND VPWR VPWR sky130_fd_sc_hd__decap_6
XFILLER_0_42_307 VGND VGND VPWR VPWR sky130_fd_sc_hd__fill_1
X_2560_ _1427_ VGND VGND VPWR VPWR _1428_ sky130_fd_sc_hd__clkbuf_4
X_2491_ _1373_ _1200_ _1181_ VGND VGND VPWR VPWR _1374_ sky130_fd_sc_hd__a21oi_1
X_4230_ clknet_leaf_1_clock _0044_ VGND VGND VPWR VPWR fifo3.mem\[7\]\[0\] sky130_fd_sc_hd__dfxtp_1
X_4161_ _1046_ regis.internal_parity\[2\] _1042_ VGND VGND VPWR VPWR _1047_ sky130_fd_sc_hd__a21boi_1
X_3112_ _0930_ _1771_ _1780_ VGND VGND VPWR VPWR _0477_ sky130_fd_sc_hd__a21o_1
X_4092_ _0992_ _0995_ _0996_ VGND VGND VPWR VPWR _0142_ sky130_fd_sc_hd__a21boi_1
X_3043_ fifo2.count\[5\] fifo2.count\[4\] fifo2.count\[3\] _1620_ VGND VGND VPWR VPWR
+ _1743_ sky130_fd_sc_hd__nor4_1
XFILLER_0_81_65 VGND VGND VPWR VPWR sky130_fd_sc_hd__decap_3
X_3945_ syn.count2\[0\] syn.count2\[1\] syn.count2\[2\] VGND VGND VPWR VPWR _0900_
+ sky130_fd_sc_hd__nand3_1
XFILLER_0_85_281 VGND VGND VPWR VPWR sky130_fd_sc_hd__decap_6
X_3876_ fsm1.ld_state fsm1.laf_state fsm1.present_state\[1\] _0720_ VGND VGND VPWR
+ VPWR _0852_ sky130_fd_sc_hd__o31ai_4
XFILLER_0_83_3 VGND VGND VPWR VPWR sky130_fd_sc_hd__fill_2
X_2827_ _1335_ _1341_ _1346_ _1348_ _0875_ VGND VGND VPWR VPWR _0438_ sky130_fd_sc_hd__o221a_2
XFILLER_0_26_370 VGND VGND VPWR VPWR sky130_fd_sc_hd__fill_2
XFILLER_0_60_115 VGND VGND VPWR VPWR sky130_fd_sc_hd__fill_1
X_2758_ _1109_ _1491_ _1492_ net61 VGND VGND VPWR VPWR _0411_ sky130_fd_sc_hd__a22o_1
X_4428_ clknet_leaf_49_clock _0017_ VGND VGND VPWR VPWR fsm1.laf_state sky130_fd_sc_hd__dfxtp_4
X_2689_ _1467_ _1438_ _0722_ fifo2.mem\[2\]\[4\] _0967_ VGND VGND VPWR VPWR _1472_
+ sky130_fd_sc_hd__o311a_1
X_4359_ clknet_leaf_47_clock _0173_ VGND VGND VPWR VPWR regis.packet_parity\[6\] sky130_fd_sc_hd__dfxtp_1
XTAP_292 VGND VPWR sky130_fd_sc_hd__tapvpwrvgnd_1
XTAP_281 VGND VPWR sky130_fd_sc_hd__tapvpwrvgnd_1
XTAP_270 VGND VPWR sky130_fd_sc_hd__tapvpwrvgnd_1
XFILLER_0_68_259 VPWR VGND VPWR VGND sky130_ef_sc_hd__decap_12
XFILLER_0_64_421 VGND VGND VPWR VPWR sky130_fd_sc_hd__fill_1
XFILLER_0_91_273 VGND VGND VPWR VPWR sky130_fd_sc_hd__decap_6
XFILLER_0_91_251 VGND VGND VPWR VPWR sky130_fd_sc_hd__fill_1
XFILLER_0_51_126 VPWR VGND VPWR VGND sky130_ef_sc_hd__decap_12
XFILLER_0_20_524 VGND VGND VPWR VPWR sky130_fd_sc_hd__decap_8
XFILLER_0_32_362 VGND VGND VPWR VPWR sky130_fd_sc_hd__fill_2
XFILLER_0_19_15 VGND VGND VPWR VPWR sky130_fd_sc_hd__decap_6
XFILLER_0_59_237 VGND VGND VPWR VPWR sky130_fd_sc_hd__decap_3
XFILLER_0_67_270 VGND VGND VPWR VPWR sky130_fd_sc_hd__decap_8
XFILLER_0_7_529 VPWR VGND VPWR VGND sky130_ef_sc_hd__decap_12
X_3730_ fifo1.data_in\[7\] VGND VGND VPWR VPWR _0744_ sky130_fd_sc_hd__clkbuf_8
XFILLER_0_51_57 VPWR VGND VPWR VGND sky130_ef_sc_hd__decap_12
XFILLER_0_67_281 VGND VGND VPWR VPWR sky130_fd_sc_hd__fill_2
X_3661_ fsm1.rst_int_reg fsm1.laf_state fsm1.present_state\[1\] VGND VGND VPWR VPWR
+ _0691_ sky130_fd_sc_hd__or3_1
X_3592_ _0610_ _0616_ _0629_ _0605_ VGND VGND VPWR VPWR _0630_ sky130_fd_sc_hd__nand4_2
X_2612_ _0734_ _0870_ _1431_ _1441_ net173 VGND VGND VPWR VPWR _0316_ sky130_fd_sc_hd__a32o_1
XFILLER_0_23_384 VGND VGND VPWR VPWR sky130_fd_sc_hd__decap_8
X_2543_ _0770_ VGND VGND VPWR VPWR _1419_ sky130_fd_sc_hd__buf_2
X_2474_ _1355_ _1356_ _1187_ VGND VGND VPWR VPWR _1357_ sky130_fd_sc_hd__a21oi_1
X_4213_ clknet_leaf_28_clock _0027_ VGND VGND VPWR VPWR fifo2.mem\[3\]\[1\] sky130_fd_sc_hd__dfxtp_1
X_4144_ _1026_ _0680_ _0656_ regis.header_byte\[5\] VGND VGND VPWR VPWR _1036_ sky130_fd_sc_hd__a31o_1
XFILLER_0_78_513 VPWR VGND VPWR VGND sky130_ef_sc_hd__decap_12
X_4075_ _0744_ _0741_ _0857_ _0975_ net70 VGND VGND VPWR VPWR _0139_ sky130_fd_sc_hd__a32o_1
X_3026_ fifo2.mem\[0\]\[7\] fifo2.mem\[1\]\[7\] fifo2.mem\[2\]\[7\] fifo2.mem\[3\]\[7\]
+ _1557_ _1540_ VGND VGND VPWR VPWR _1727_ sky130_fd_sc_hd__mux4_1
XFILLER_0_58_270 VPWR VGND VPWR VGND sky130_ef_sc_hd__decap_12
XFILLER_0_18_134 VGND VGND VPWR VPWR sky130_fd_sc_hd__decap_6
X_3928_ syn.count1\[0\] syn.count1\[1\] syn.count1\[2\] syn.count1\[3\] syn.count1\[4\]
+ VGND VGND VPWR VPWR _0888_ sky130_fd_sc_hd__a41o_1
X_3859_ _0839_ _0840_ _0841_ _0842_ fifo3.mem\[1\]\[1\] VGND VGND VPWR VPWR _0843_
+ sky130_fd_sc_hd__o311a_1
XFILLER_0_61_435 VPWR VGND VPWR VGND sky130_ef_sc_hd__decap_12
XFILLER_0_33_148 VGND VGND VPWR VPWR sky130_fd_sc_hd__fill_2
XFILLER_0_14_384 VGND VGND VPWR VPWR sky130_fd_sc_hd__decap_3
XFILLER_0_41_192 VGND VGND VPWR VPWR sky130_fd_sc_hd__decap_4
XFILLER_0_69_502 VGND VGND VPWR VPWR sky130_fd_sc_hd__fill_2
XFILLER_0_69_513 VGND VGND VPWR VPWR sky130_fd_sc_hd__fill_2
Xclkbuf_leaf_12_clock clknet_3_2__leaf_clock VGND VGND VPWR VPWR clknet_leaf_12_clock
+ sky130_fd_sc_hd__clkbuf_16
XFILLER_0_56_207 VGND VGND VPWR VPWR sky130_fd_sc_hd__fill_1
XFILLER_0_37_443 VGND VGND VPWR VPWR sky130_fd_sc_hd__decap_4
XFILLER_0_21_27 VGND VGND VPWR VPWR sky130_fd_sc_hd__decap_6
XFILLER_0_64_295 VPWR VGND VPWR VGND sky130_ef_sc_hd__decap_12
Xclkbuf_leaf_27_clock clknet_3_6__leaf_clock VGND VGND VPWR VPWR clknet_leaf_27_clock
+ sky130_fd_sc_hd__clkbuf_16
XFILLER_0_20_332 VGND VGND VPWR VPWR sky130_fd_sc_hd__fill_1
X_2190_ _1107_ _1117_ _1118_ net164 VGND VGND VPWR VPWR _0217_ sky130_fd_sc_hd__a22o_1
XFILLER_0_1_15 VPWR VGND VPWR VGND sky130_ef_sc_hd__decap_12
XFILLER_0_75_505 VGND VGND VPWR VPWR sky130_fd_sc_hd__fill_2
XFILLER_0_7_337 VGND VGND VPWR VPWR sky130_fd_sc_hd__decap_3
X_4762_ clknet_leaf_38_clock _0568_ VGND VGND VPWR VPWR fifo2.mem\[11\]\[8\] sky130_fd_sc_hd__dfxtp_1
X_3713_ _0732_ _0715_ _0724_ _0730_ net86 VGND VGND VPWR VPWR _0027_ sky130_fd_sc_hd__a32o_1
X_4693_ clknet_leaf_18_clock _0499_ VGND VGND VPWR VPWR fifo1.mem\[15\]\[3\] sky130_fd_sc_hd__dfxtp_1
X_3644_ _0618_ _0628_ _0630_ _0647_ VGND VGND VPWR VPWR _0678_ sky130_fd_sc_hd__o211ai_4
XFILLER_0_70_265 VPWR VGND VPWR VGND sky130_ef_sc_hd__decap_12
X_3575_ fifo1.rd_pointer\[3\] _0613_ VGND VGND VPWR VPWR _0614_ sky130_fd_sc_hd__nor2_1
XFILLER_0_87_64 VGND VGND VPWR VPWR sky130_fd_sc_hd__decap_8
X_2526_ fifo3.rd_pointer\[1\] _0637_ _1404_ VGND VGND VPWR VPWR _1406_ sky130_fd_sc_hd__nand3_1
X_2457_ _1200_ _1340_ _0003_ VGND VGND VPWR VPWR _1341_ sky130_fd_sc_hd__o21ai_2
Xhold28 fifo1.mem\[13\]\[4\] VGND VGND VPWR VPWR net76 sky130_fd_sc_hd__dlygate4sd3_1
Xhold17 fifo2.mem\[0\]\[8\] VGND VGND VPWR VPWR net65 sky130_fd_sc_hd__dlygate4sd3_1
XFILLER_0_46_3 VPWR VGND VPWR VGND sky130_ef_sc_hd__decap_12
Xhold39 fifo1.mem\[0\]\[0\] VGND VGND VPWR VPWR net87 sky130_fd_sc_hd__dlygate4sd3_1
X_2388_ fifo1.mem\[11\]\[4\] _1220_ _1273_ VGND VGND VPWR VPWR _1274_ sky130_fd_sc_hd__o21ai_1
X_4127_ regis.header_byte\[7\] _0684_ _1024_ _0988_ VGND VGND VPWR VPWR _1025_ sky130_fd_sc_hd__o2bb2a_1
X_4058_ fifo2.soft_reset _0652_ VGND VGND VPWR VPWR _0973_ sky130_fd_sc_hd__or2b_1
X_3009_ _1705_ _1623_ _1625_ _1710_ VGND VGND VPWR VPWR _1711_ sky130_fd_sc_hd__a211oi_1
XFILLER_0_38_207 VGND VGND VPWR VPWR sky130_fd_sc_hd__decap_4
XFILLER_0_34_413 VGND VGND VPWR VPWR sky130_fd_sc_hd__decap_6
XFILLER_0_6_381 VPWR VGND VPWR VGND sky130_ef_sc_hd__decap_12
XFILLER_0_14_170 VGND VGND VPWR VPWR sky130_fd_sc_hd__fill_1
XFILLER_0_16_49 VGND VGND VPWR VPWR sky130_fd_sc_hd__fill_1
XTAP_1030 VGND VPWR sky130_fd_sc_hd__tapvpwrvgnd_1
XFILLER_0_57_505 VGND VGND VPWR VPWR sky130_fd_sc_hd__fill_2
XTAP_1074 VGND VPWR sky130_fd_sc_hd__tapvpwrvgnd_1
XTAP_1063 VGND VPWR sky130_fd_sc_hd__tapvpwrvgnd_1
XTAP_1052 VGND VPWR sky130_fd_sc_hd__tapvpwrvgnd_1
XTAP_1041 VGND VPWR sky130_fd_sc_hd__tapvpwrvgnd_1
XFILLER_0_32_15 VPWR VGND VPWR VGND sky130_ef_sc_hd__decap_12
XFILLER_0_37_240 VGND VGND VPWR VPWR sky130_fd_sc_hd__decap_3
XFILLER_0_0_513 VGND VGND VPWR VPWR sky130_fd_sc_hd__fill_1
X_3360_ _1980_ _0694_ _0799_ _1981_ VGND VGND VPWR VPWR _1982_ sky130_fd_sc_hd__and4b_1
X_2311_ _1186_ _1180_ _1198_ VGND VGND VPWR VPWR _1199_ sky130_fd_sc_hd__a21oi_2
XFILLER_0_57_34 VGND VGND VPWR VPWR sky130_fd_sc_hd__decap_4
XTAP_803 VGND VPWR sky130_fd_sc_hd__tapvpwrvgnd_1
XTAP_814 VGND VPWR sky130_fd_sc_hd__tapvpwrvgnd_1
XTAP_825 VGND VPWR sky130_fd_sc_hd__tapvpwrvgnd_1
X_3291_ _1828_ fifo3.mem\[4\]\[5\] _1835_ VGND VGND VPWR VPWR _1918_ sky130_fd_sc_hd__o21bai_1
XTAP_836 VGND VPWR sky130_fd_sc_hd__tapvpwrvgnd_1
XTAP_847 VGND VPWR sky130_fd_sc_hd__tapvpwrvgnd_1
XTAP_858 VGND VPWR sky130_fd_sc_hd__tapvpwrvgnd_1
X_2242_ _1106_ _1141_ _1144_ net106 VGND VGND VPWR VPWR _0243_ sky130_fd_sc_hd__a22o_1
XTAP_869 VGND VPWR sky130_fd_sc_hd__tapvpwrvgnd_1
X_2173_ _1110_ _1114_ _1115_ net127 VGND VGND VPWR VPWR _0203_ sky130_fd_sc_hd__a22o_1
XFILLER_0_28_284 VGND VGND VPWR VPWR sky130_fd_sc_hd__fill_1
X_4745_ clknet_leaf_52_clock _0551_ VGND VGND VPWR VPWR fifo3.mem\[0\]\[0\] sky130_fd_sc_hd__dfxtp_1
XFILLER_0_7_167 VGND VGND VPWR VPWR sky130_fd_sc_hd__fill_1
X_4676_ clknet_leaf_59_clock _0482_ VGND VGND VPWR VPWR fifo3.mem\[9\]\[8\] sky130_fd_sc_hd__dfxtp_1
X_3627_ _0659_ _0660_ _0658_ VGND VGND VPWR VPWR _0664_ sky130_fd_sc_hd__and3b_1
X_3558_ _0731_ _2105_ _0920_ _2106_ net59 VGND VGND VPWR VPWR _0597_ sky130_fd_sc_hd__a32o_1
XFILLER_0_3_373 VPWR VGND VPWR VGND sky130_ef_sc_hd__decap_12
Xoutput18 net18 VGND VGND VPWR VPWR data_out_0[3] sky130_fd_sc_hd__clkbuf_4
Xoutput29 net29 VGND VGND VPWR VPWR data_out_1[6] sky130_fd_sc_hd__buf_2
X_2509_ net10 _1391_ net40 _1195_ VGND VGND VPWR VPWR _1392_ sky130_fd_sc_hd__a31o_1
XFILLER_0_11_173 VGND VGND VPWR VPWR sky130_fd_sc_hd__fill_1
X_3489_ _2072_ _0783_ net273 _2078_ VGND VGND VPWR VPWR _0556_ sky130_fd_sc_hd__a31o_1
XFILLER_0_39_505 VPWR VGND VPWR VGND sky130_ef_sc_hd__decap_12
XPHY_102 VGND VGND VPWR VPWR sky130_fd_sc_hd__decap_3
XPHY_113 VGND VGND VPWR VPWR sky130_fd_sc_hd__decap_3
XPHY_124 VGND VGND VPWR VPWR sky130_fd_sc_hd__decap_3
XPHY_157 VGND VGND VPWR VPWR sky130_fd_sc_hd__decap_3
XPHY_146 VGND VGND VPWR VPWR sky130_fd_sc_hd__decap_3
XPHY_135 VGND VGND VPWR VPWR sky130_fd_sc_hd__decap_3
XPHY_179 VGND VGND VPWR VPWR sky130_fd_sc_hd__decap_3
XPHY_168 VGND VGND VPWR VPWR sky130_fd_sc_hd__decap_3
XFILLER_0_81_349 VPWR VGND VPWR VGND sky130_ef_sc_hd__decap_12
XFILLER_0_34_265 VGND VGND VPWR VPWR sky130_fd_sc_hd__decap_8
XFILLER_0_27_15 VPWR VGND VPWR VGND sky130_ef_sc_hd__decap_12
XFILLER_0_89_449 VPWR VGND VPWR VGND sky130_ef_sc_hd__decap_12
XPHY_4 VGND VGND VPWR VPWR sky130_fd_sc_hd__decap_3
XFILLER_0_43_69 VPWR VGND VPWR VGND sky130_ef_sc_hd__decap_12
X_2860_ _1550_ fifo2.mem\[2\]\[2\] _1562_ VGND VGND VPWR VPWR _1566_ sky130_fd_sc_hd__o21ai_1
X_2791_ fifo2.soft_reset _1506_ _1507_ _1508_ VGND VGND VPWR VPWR _1509_ sky130_fd_sc_hd__nor4_1
XFILLER_0_13_405 VGND VGND VPWR VPWR sky130_fd_sc_hd__decap_6
X_4530_ clknet_leaf_22_clock _0336_ VGND VGND VPWR VPWR fifo2.mem\[7\]\[4\] sky130_fd_sc_hd__dfxtp_1
X_4461_ clknet_leaf_51_clock _0267_ VGND VGND VPWR VPWR _0010_ sky130_fd_sc_hd__dfxtp_4
XFILLER_0_40_235 VGND VGND VPWR VPWR sky130_fd_sc_hd__decap_4
XFILLER_0_7_69 VPWR VGND VPWR VGND sky130_ef_sc_hd__decap_12
XFILLER_0_0_321 VPWR VGND VPWR VGND sky130_ef_sc_hd__decap_12
X_3412_ _2012_ _1809_ _2017_ VGND VGND VPWR VPWR _2018_ sky130_fd_sc_hd__a21o_1
XTAP_600 VGND VPWR sky130_fd_sc_hd__tapvpwrvgnd_1
X_4392_ clknet_leaf_12_clock _0206_ VGND VGND VPWR VPWR fifo1.mem\[2\]\[3\] sky130_fd_sc_hd__dfxtp_1
XFILLER_0_0_365 VPWR VGND VPWR VGND sky130_ef_sc_hd__decap_12
X_3343_ _1812_ _1967_ VGND VGND VPWR VPWR _1968_ sky130_fd_sc_hd__nand2_1
XTAP_611 VGND VPWR sky130_fd_sc_hd__tapvpwrvgnd_1
XTAP_622 VGND VPWR sky130_fd_sc_hd__tapvpwrvgnd_1
XTAP_633 VGND VPWR sky130_fd_sc_hd__tapvpwrvgnd_1
X_3274_ fifo3.mem\[11\]\[4\] _1838_ _1901_ VGND VGND VPWR VPWR _1902_ sky130_fd_sc_hd__o21ai_1
XTAP_644 VGND VPWR sky130_fd_sc_hd__tapvpwrvgnd_1
XTAP_655 VGND VPWR sky130_fd_sc_hd__tapvpwrvgnd_1
XTAP_666 VGND VPWR sky130_fd_sc_hd__tapvpwrvgnd_1
XTAP_677 VGND VPWR sky130_fd_sc_hd__tapvpwrvgnd_1
X_2225_ net229 _1137_ _1139_ _0926_ VGND VGND VPWR VPWR _0231_ sky130_fd_sc_hd__a22o_1
XTAP_688 VGND VPWR sky130_fd_sc_hd__tapvpwrvgnd_1
XTAP_699 VGND VPWR sky130_fd_sc_hd__tapvpwrvgnd_1
XFILLER_0_17_70 VGND VGND VPWR VPWR sky130_fd_sc_hd__fill_1
X_2156_ _0735_ VGND VGND VPWR VPWR _1105_ sky130_fd_sc_hd__clkbuf_4
XFILLER_0_8_421 VGND VGND VPWR VPWR sky130_fd_sc_hd__decap_8
X_2989_ _1538_ _1672_ _1678_ _1684_ _1691_ VGND VGND VPWR VPWR _1692_ sky130_fd_sc_hd__a32oi_4
X_4728_ clknet_leaf_29_clock _0534_ VGND VGND VPWR VPWR net25 sky130_fd_sc_hd__dfxtp_1
XFILLER_0_71_393 VPWR VGND VPWR VGND sky130_ef_sc_hd__decap_12
X_4659_ clknet_leaf_2_clock _0465_ VGND VGND VPWR VPWR fifo3.mem\[2\]\[0\] sky130_fd_sc_hd__dfxtp_1
XFILLER_0_31_279 VGND VGND VPWR VPWR sky130_fd_sc_hd__fill_1
XFILLER_0_86_419 VGND VGND VPWR VPWR sky130_fd_sc_hd__fill_1
XFILLER_0_50_533 VGND VGND VPWR VPWR sky130_fd_sc_hd__decap_8
XFILLER_0_1_129 VPWR VGND VPWR VGND sky130_ef_sc_hd__decap_12
XFILLER_0_22_257 VGND VGND VPWR VPWR sky130_fd_sc_hd__fill_1
X_3961_ _0659_ regis.fifo_full_state\[0\] _0910_ VGND VGND VPWR VPWR _0911_ sky130_fd_sc_hd__mux2_1
X_2912_ _1588_ _1616_ VGND VGND VPWR VPWR _1617_ sky130_fd_sc_hd__nand2_1
XFILLER_0_85_485 VPWR VGND VPWR VGND sky130_ef_sc_hd__decap_12
X_3892_ _0855_ _0856_ fifo2.mem\[8\]\[3\] _0857_ _0864_ VGND VGND VPWR VPWR _0074_
+ sky130_fd_sc_hd__a32o_1
XFILLER_0_72_124 VGND VGND VPWR VPWR sky130_fd_sc_hd__decap_6
X_2843_ _1547_ _1548_ _1537_ VGND VGND VPWR VPWR _1549_ sky130_fd_sc_hd__a21oi_1
XFILLER_0_5_446 VGND VGND VPWR VPWR sky130_fd_sc_hd__fill_2
X_2774_ _0628_ _0721_ _0727_ _0726_ VGND VGND VPWR VPWR _1497_ sky130_fd_sc_hd__a31o_1
XFILLER_0_79_54 VGND VGND VPWR VPWR sky130_fd_sc_hd__fill_2
X_4513_ clknet_leaf_33_clock _0319_ VGND VGND VPWR VPWR fifo2.mem\[9\]\[5\] sky130_fd_sc_hd__dfxtp_1
Xhold103 fifo2.mem\[11\]\[4\] VGND VGND VPWR VPWR net151 sky130_fd_sc_hd__dlygate4sd3_1
Xhold125 fifo2.mem\[9\]\[2\] VGND VGND VPWR VPWR net173 sky130_fd_sc_hd__dlygate4sd3_1
Xhold114 fifo1.mem\[11\]\[4\] VGND VGND VPWR VPWR net162 sky130_fd_sc_hd__dlygate4sd3_1
XFILLER_0_13_279 VGND VGND VPWR VPWR sky130_fd_sc_hd__fill_1
Xhold136 fifo3.mem\[3\]\[5\] VGND VGND VPWR VPWR net184 sky130_fd_sc_hd__dlygate4sd3_1
Xhold158 fifo1.mem\[4\]\[0\] VGND VGND VPWR VPWR net206 sky130_fd_sc_hd__dlygate4sd3_1
X_4444_ clknet_leaf_5_clock _0250_ VGND VGND VPWR VPWR fifo1.wr_pointer\[2\] sky130_fd_sc_hd__dfxtp_1
Xhold147 fifo1.mem\[8\]\[7\] VGND VGND VPWR VPWR net195 sky130_fd_sc_hd__dlygate4sd3_1
Xhold169 fifo2.mem\[11\]\[3\] VGND VGND VPWR VPWR net217 sky130_fd_sc_hd__dlygate4sd3_1
X_4375_ clknet_leaf_9_clock _0189_ VGND VGND VPWR VPWR fifo1.mem\[9\]\[4\] sky130_fd_sc_hd__dfxtp_1
X_3326_ _1948_ _1949_ _1950_ _1951_ VGND VGND VPWR VPWR _1952_ sky130_fd_sc_hd__o22a_1
XTAP_430 VGND VPWR sky130_fd_sc_hd__tapvpwrvgnd_1
XTAP_441 VGND VPWR sky130_fd_sc_hd__tapvpwrvgnd_1
XTAP_452 VGND VPWR sky130_fd_sc_hd__tapvpwrvgnd_1
XTAP_463 VGND VPWR sky130_fd_sc_hd__tapvpwrvgnd_1
XTAP_474 VGND VPWR sky130_fd_sc_hd__tapvpwrvgnd_1
XTAP_485 VGND VPWR sky130_fd_sc_hd__tapvpwrvgnd_1
X_3257_ _1884_ _1832_ _1885_ VGND VGND VPWR VPWR _1886_ sky130_fd_sc_hd__a21oi_1
XTAP_496 VGND VPWR sky130_fd_sc_hd__tapvpwrvgnd_1
X_3188_ _1810_ _1815_ _1816_ _1819_ _0875_ VGND VGND VPWR VPWR _0514_ sky130_fd_sc_hd__o221a_1
X_2208_ _1126_ _1120_ fifo1.mem\[7\]\[3\] VGND VGND VPWR VPWR _1130_ sky130_fd_sc_hd__and3_1
X_2139_ _1098_ _1096_ _1097_ net113 VGND VGND VPWR VPWR _0186_ sky130_fd_sc_hd__a22o_1
XFILLER_0_68_419 VGND VGND VPWR VPWR sky130_fd_sc_hd__fill_1
XFILLER_0_76_474 VGND VGND VPWR VPWR sky130_fd_sc_hd__fill_2
XFILLER_0_91_477 VGND VGND VPWR VPWR sky130_fd_sc_hd__fill_2
XFILLER_0_32_533 VGND VGND VPWR VPWR sky130_fd_sc_hd__decap_8
XFILLER_0_24_27 VGND VGND VPWR VPWR sky130_fd_sc_hd__fill_1
XFILLER_0_67_441 VGND VGND VPWR VPWR sky130_fd_sc_hd__decap_4
XFILLER_0_82_433 VGND VGND VPWR VPWR sky130_fd_sc_hd__decap_4
XFILLER_0_40_15 VPWR VGND VPWR VGND sky130_ef_sc_hd__decap_12
XFILLER_0_67_496 VGND VGND VPWR VPWR sky130_fd_sc_hd__fill_1
XFILLER_0_82_477 VPWR VGND VPWR VGND sky130_ef_sc_hd__decap_12
XFILLER_0_23_500 VGND VGND VPWR VPWR sky130_fd_sc_hd__decap_4
XFILLER_0_35_393 VGND VGND VPWR VPWR sky130_fd_sc_hd__fill_2
XFILLER_0_10_205 VGND VGND VPWR VPWR sky130_fd_sc_hd__fill_1
XFILLER_0_50_363 VGND VGND VPWR VPWR sky130_fd_sc_hd__fill_1
X_2490_ fifo1.mem\[4\]\[7\] fifo1.mem\[5\]\[7\] fifo1.mem\[6\]\[7\] fifo1.mem\[7\]\[7\]
+ _1296_ _1183_ VGND VGND VPWR VPWR _1373_ sky130_fd_sc_hd__mux4_1
XFILLER_0_10_249 VGND VGND VPWR VPWR sky130_fd_sc_hd__decap_3
X_4160_ regis.header_byte\[2\] _0993_ _1040_ net3 VGND VGND VPWR VPWR _1046_ sky130_fd_sc_hd__a22o_1
XFILLER_0_4_15 VPWR VGND VPWR VGND sky130_ef_sc_hd__decap_12
X_3111_ _0839_ _1779_ _1774_ fifo3.mem\[9\]\[3\] _1775_ VGND VGND VPWR VPWR _1780_
+ sky130_fd_sc_hd__o311a_1
X_4091_ _0694_ VGND VGND VPWR VPWR _0996_ sky130_fd_sc_hd__buf_4
X_3042_ _1738_ _1741_ _1742_ VGND VGND VPWR VPWR _0445_ sky130_fd_sc_hd__a21oi_1
X_3944_ syn.count2\[0\] syn.count2\[1\] syn.count2\[2\] VGND VGND VPWR VPWR _0899_
+ sky130_fd_sc_hd__a21o_1
XFILLER_0_14_82 VGND VGND VPWR VPWR sky130_fd_sc_hd__fill_2
X_3875_ _0726_ _0727_ VGND VGND VPWR VPWR _0851_ sky130_fd_sc_hd__nor2_4
XFILLER_0_45_157 VGND VGND VPWR VPWR sky130_fd_sc_hd__fill_1
X_2826_ _1534_ VGND VGND VPWR VPWR _0437_ sky130_fd_sc_hd__clkbuf_1
XFILLER_0_14_533 VGND VGND VPWR VPWR sky130_fd_sc_hd__decap_8
X_2757_ _1108_ _1491_ _1492_ net260 VGND VGND VPWR VPWR _0410_ sky130_fd_sc_hd__a22o_1
XFILLER_0_5_265 VPWR VGND VPWR VGND sky130_ef_sc_hd__decap_12
XFILLER_0_76_3 VPWR VGND VPWR VGND sky130_ef_sc_hd__decap_12
X_2688_ _0761_ _0960_ _1436_ _1471_ VGND VGND VPWR VPWR _0362_ sky130_fd_sc_hd__a31o_1
X_4427_ clknet_leaf_50_clock _0016_ VGND VGND VPWR VPWR fifo1.lfd_state sky130_fd_sc_hd__dfxtp_2
X_4358_ clknet_leaf_43_clock _0172_ VGND VGND VPWR VPWR regis.packet_parity\[5\] sky130_fd_sc_hd__dfxtp_1
XTAP_260 VGND VPWR sky130_fd_sc_hd__tapvpwrvgnd_1
X_4289_ clknet_leaf_46_clock _0103_ VGND VGND VPWR VPWR regis.fifo_full_state\[6\]
+ sky130_fd_sc_hd__dfxtp_1
XTAP_293 VGND VPWR sky130_fd_sc_hd__tapvpwrvgnd_1
X_3309_ _1849_ fifo3.mem\[12\]\[5\] _1835_ VGND VGND VPWR VPWR _1936_ sky130_fd_sc_hd__o21bai_1
XTAP_282 VGND VPWR sky130_fd_sc_hd__tapvpwrvgnd_1
XTAP_271 VGND VPWR sky130_fd_sc_hd__tapvpwrvgnd_1
XFILLER_0_49_441 VGND VGND VPWR VPWR sky130_fd_sc_hd__decap_3
XFILLER_0_36_179 VGND VGND VPWR VPWR sky130_fd_sc_hd__fill_1
XFILLER_0_51_138 VGND VGND VPWR VPWR sky130_fd_sc_hd__fill_1
XFILLER_0_10_29 VPWR VGND VPWR VGND sky130_ef_sc_hd__decap_12
XFILLER_0_87_503 VGND VGND VPWR VPWR sky130_fd_sc_hd__fill_1
XFILLER_0_51_69 VPWR VGND VPWR VGND sky130_ef_sc_hd__decap_12
X_3660_ fifo1.lfd_state VGND VGND VPWR VPWR _0690_ sky130_fd_sc_hd__buf_2
XFILLER_0_2_202 VGND VGND VPWR VPWR sky130_fd_sc_hd__decap_8
X_3591_ fsm1.addr\[1\] fsm1.addr\[0\] VGND VGND VPWR VPWR _0629_ sky130_fd_sc_hd__nor2_1
XFILLER_0_42_138 VGND VGND VPWR VPWR sky130_fd_sc_hd__fill_2
X_2611_ _0732_ _0870_ _1431_ _1441_ net60 VGND VGND VPWR VPWR _0315_ sky130_fd_sc_hd__a32o_1
XFILLER_0_2_235 VGND VGND VPWR VPWR sky130_fd_sc_hd__fill_1
X_2542_ _0713_ _1416_ _0837_ _1418_ net101 VGND VGND VPWR VPWR _0269_ sky130_fd_sc_hd__a32o_1
X_2473_ _1320_ fifo1.mem\[13\]\[5\] _1310_ VGND VGND VPWR VPWR _1356_ sky130_fd_sc_hd__o21ai_1
X_4212_ clknet_leaf_28_clock _0026_ VGND VGND VPWR VPWR fifo2.mem\[3\]\[0\] sky130_fd_sc_hd__dfxtp_1
X_4143_ _0694_ VGND VGND VPWR VPWR _1035_ sky130_fd_sc_hd__clkbuf_4
X_4074_ _0976_ _0981_ net296 _0982_ VGND VGND VPWR VPWR _0138_ sky130_fd_sc_hd__a31o_1
X_3025_ _1725_ _1623_ _1625_ VGND VGND VPWR VPWR _1726_ sky130_fd_sc_hd__a21oi_1
XFILLER_0_78_525 VGND VGND VPWR VPWR sky130_fd_sc_hd__decap_6
XFILLER_0_58_282 VGND VGND VPWR VPWR sky130_fd_sc_hd__fill_1
X_3927_ _0887_ VGND VGND VPWR VPWR _0086_ sky130_fd_sc_hd__clkbuf_1
XFILLER_0_73_241 VGND VGND VPWR VPWR sky130_fd_sc_hd__decap_4
X_3858_ _0781_ VGND VGND VPWR VPWR _0842_ sky130_fd_sc_hd__clkbuf_4
Xclkbuf_leaf_8_clock clknet_3_2__leaf_clock VGND VGND VPWR VPWR clknet_leaf_8_clock
+ sky130_fd_sc_hd__clkbuf_16
X_3789_ _0789_ VGND VGND VPWR VPWR _0790_ sky130_fd_sc_hd__buf_4
X_2809_ fifo1.mem\[8\]\[0\] fifo1.mem\[9\]\[0\] fifo1.mem\[10\]\[0\] fifo1.mem\[11\]\[0\]
+ _1317_ _1339_ VGND VGND VPWR VPWR _1523_ sky130_fd_sc_hd__mux4_2
XFILLER_0_61_447 VGND VGND VPWR VPWR sky130_fd_sc_hd__fill_1
XFILLER_0_14_363 VGND VGND VPWR VPWR sky130_fd_sc_hd__fill_1
XFILLER_0_52_403 VGND VGND VPWR VPWR sky130_fd_sc_hd__fill_2
XFILLER_0_52_469 VGND VGND VPWR VPWR sky130_fd_sc_hd__fill_1
XFILLER_0_20_344 VGND VGND VPWR VPWR sky130_fd_sc_hd__fill_1
XFILLER_0_20_377 VGND VGND VPWR VPWR sky130_fd_sc_hd__fill_1
XFILLER_0_1_27 VPWR VGND VPWR VGND sky130_ef_sc_hd__decap_12
XFILLER_0_28_466 VGND VGND VPWR VPWR sky130_fd_sc_hd__fill_1
X_4761_ clknet_leaf_38_clock _0567_ VGND VGND VPWR VPWR fifo2.mem\[11\]\[7\] sky130_fd_sc_hd__dfxtp_1
XFILLER_0_28_477 VPWR VGND VPWR VGND sky130_ef_sc_hd__decap_12
X_3712_ _0731_ VGND VGND VPWR VPWR _0732_ sky130_fd_sc_hd__buf_4
X_4692_ clknet_leaf_18_clock _0498_ VGND VGND VPWR VPWR fifo1.mem\[15\]\[2\] sky130_fd_sc_hd__dfxtp_1
X_3643_ fsm1.laf_state VGND VGND VPWR VPWR _0677_ sky130_fd_sc_hd__inv_2
XFILLER_0_43_447 VGND VGND VPWR VPWR sky130_fd_sc_hd__fill_1
XFILLER_0_11_94 VGND VGND VPWR VPWR sky130_fd_sc_hd__decap_8
XFILLER_0_70_277 VGND VGND VPWR VPWR sky130_fd_sc_hd__decap_3
X_3574_ fifo1.wr_pointer\[3\] VGND VGND VPWR VPWR _0613_ sky130_fd_sc_hd__buf_2
X_2525_ _0637_ _1404_ _1405_ VGND VGND VPWR VPWR _0265_ sky130_fd_sc_hd__a21oi_1
XFILLER_0_87_98 VPWR VGND VPWR VGND sky130_ef_sc_hd__decap_12
XFILLER_0_11_377 VPWR VGND VPWR VGND sky130_ef_sc_hd__decap_12
X_2456_ _1336_ _1337_ _1338_ _1339_ VGND VGND VPWR VPWR _1340_ sky130_fd_sc_hd__a22oi_2
Xhold18 fifo3.mem\[13\]\[5\] VGND VGND VPWR VPWR net66 sky130_fd_sc_hd__dlygate4sd3_1
Xhold29 fifo3.mem\[15\]\[0\] VGND VGND VPWR VPWR net77 sky130_fd_sc_hd__dlygate4sd3_1
X_4126_ fifo1.lfd_state fifo1.data_in\[7\] VGND VGND VPWR VPWR _1024_ sky130_fd_sc_hd__or2b_1
XFILLER_0_39_3 VPWR VGND VPWR VGND sky130_ef_sc_hd__decap_12
X_2387_ _1232_ fifo1.mem\[10\]\[4\] _1233_ VGND VGND VPWR VPWR _1273_ sky130_fd_sc_hd__o21a_1
X_4057_ _0717_ VGND VGND VPWR VPWR _0972_ sky130_fd_sc_hd__clkbuf_4
X_3008_ _1707_ _1709_ _1542_ VGND VGND VPWR VPWR _1710_ sky130_fd_sc_hd__a21oi_1
XFILLER_0_46_230 VGND VGND VPWR VPWR sky130_fd_sc_hd__fill_2
XFILLER_0_34_469 VGND VGND VPWR VPWR sky130_fd_sc_hd__decap_6
XFILLER_0_6_393 VPWR VGND VPWR VGND sky130_ef_sc_hd__decap_12
XFILLER_0_21_108 VGND VGND VPWR VPWR sky130_fd_sc_hd__decap_4
XTAP_1031 VGND VPWR sky130_fd_sc_hd__tapvpwrvgnd_1
XTAP_1020 VGND VPWR sky130_fd_sc_hd__tapvpwrvgnd_1
XFILLER_0_29_208 VGND VGND VPWR VPWR sky130_fd_sc_hd__decap_8
XTAP_1064 VGND VPWR sky130_fd_sc_hd__tapvpwrvgnd_1
XTAP_1053 VGND VPWR sky130_fd_sc_hd__tapvpwrvgnd_1
XTAP_1042 VGND VPWR sky130_fd_sc_hd__tapvpwrvgnd_1
XFILLER_0_32_27 VGND VGND VPWR VPWR sky130_fd_sc_hd__fill_1
XTAP_1075 VGND VPWR sky130_fd_sc_hd__tapvpwrvgnd_1
XFILLER_0_80_531 VGND VGND VPWR VPWR sky130_fd_sc_hd__fill_1
X_2310_ _1197_ VGND VGND VPWR VPWR _1198_ sky130_fd_sc_hd__buf_4
X_3290_ fifo3.mem\[5\]\[5\] VGND VGND VPWR VPWR _1917_ sky130_fd_sc_hd__inv_2
XTAP_804 VGND VPWR sky130_fd_sc_hd__tapvpwrvgnd_1
XTAP_815 VGND VPWR sky130_fd_sc_hd__tapvpwrvgnd_1
XTAP_826 VGND VPWR sky130_fd_sc_hd__tapvpwrvgnd_1
X_2241_ _1105_ _1141_ _1144_ net159 VGND VGND VPWR VPWR _0242_ sky130_fd_sc_hd__a22o_1
XTAP_837 VGND VPWR sky130_fd_sc_hd__tapvpwrvgnd_1
XTAP_848 VGND VPWR sky130_fd_sc_hd__tapvpwrvgnd_1
XTAP_859 VGND VPWR sky130_fd_sc_hd__tapvpwrvgnd_1
X_2172_ _1102_ _1114_ VGND VGND VPWR VPWR _1115_ sky130_fd_sc_hd__nor2_4
XFILLER_0_73_89 VGND VGND VPWR VPWR sky130_fd_sc_hd__decap_8
XFILLER_0_87_163 VGND VGND VPWR VPWR sky130_fd_sc_hd__decap_4
XFILLER_0_87_152 VGND VGND VPWR VPWR sky130_fd_sc_hd__decap_3
XFILLER_0_75_303 VGND VGND VPWR VPWR sky130_fd_sc_hd__fill_1
XFILLER_0_48_517 VPWR VGND VPWR VGND sky130_ef_sc_hd__decap_12
XFILLER_0_7_113 VGND VGND VPWR VPWR sky130_fd_sc_hd__decap_4
X_4744_ clknet_leaf_18_clock _0550_ VGND VGND VPWR VPWR _0003_ sky130_fd_sc_hd__dfxtp_2
XFILLER_0_83_391 VGND VGND VPWR VPWR sky130_fd_sc_hd__fill_1
XFILLER_0_7_179 VGND VGND VPWR VPWR sky130_fd_sc_hd__fill_1
X_4675_ clknet_leaf_59_clock _0481_ VGND VGND VPWR VPWR fifo3.mem\[9\]\[7\] sky130_fd_sc_hd__dfxtp_1
X_3626_ _0663_ VGND VGND VPWR VPWR net41 sky130_fd_sc_hd__clkbuf_8
X_3557_ _0712_ _2105_ _0920_ _2106_ net98 VGND VGND VPWR VPWR _0596_ sky130_fd_sc_hd__a32o_1
Xoutput19 net19 VGND VGND VPWR VPWR data_out_0[4] sky130_fd_sc_hd__clkbuf_4
XFILLER_0_3_385 VGND VGND VPWR VPWR sky130_fd_sc_hd__decap_6
X_2508_ fifo1.count\[5\] _1328_ VGND VGND VPWR VPWR _1391_ sky130_fd_sc_hd__xnor2_1
XFILLER_0_11_152 VGND VGND VPWR VPWR sky130_fd_sc_hd__decap_4
Xclkbuf_leaf_11_clock clknet_3_2__leaf_clock VGND VGND VPWR VPWR clknet_leaf_11_clock
+ sky130_fd_sc_hd__clkbuf_16
X_3488_ _0739_ _2070_ net45 VGND VGND VPWR VPWR _2078_ sky130_fd_sc_hd__and3_1
X_2439_ _1198_ _1302_ _1309_ _1315_ _1323_ VGND VGND VPWR VPWR _1324_ sky130_fd_sc_hd__a32oi_4
Xclkbuf_leaf_26_clock clknet_3_6__leaf_clock VGND VGND VPWR VPWR clknet_leaf_26_clock
+ sky130_fd_sc_hd__clkbuf_16
X_4109_ regis.fifo_full_state\[4\] _0990_ _0690_ VGND VGND VPWR VPWR _1010_ sky130_fd_sc_hd__o21ba_1
XFILLER_0_2_70 VPWR VGND VPWR VGND sky130_ef_sc_hd__decap_12
XFILLER_0_78_141 VGND VGND VPWR VPWR sky130_fd_sc_hd__fill_1
XFILLER_0_39_517 VPWR VGND VPWR VGND sky130_ef_sc_hd__decap_12
XFILLER_0_78_174 VGND VGND VPWR VPWR sky130_fd_sc_hd__decap_6
XPHY_103 VGND VGND VPWR VPWR sky130_fd_sc_hd__decap_3
XPHY_114 VGND VGND VPWR VPWR sky130_fd_sc_hd__decap_3
XPHY_125 VGND VGND VPWR VPWR sky130_fd_sc_hd__decap_3
XPHY_158 VGND VGND VPWR VPWR sky130_fd_sc_hd__decap_3
XPHY_147 VGND VGND VPWR VPWR sky130_fd_sc_hd__decap_3
XPHY_136 VGND VGND VPWR VPWR sky130_fd_sc_hd__decap_3
XPHY_169 VGND VGND VPWR VPWR sky130_fd_sc_hd__decap_3
XFILLER_0_81_317 VPWR VGND VPWR VGND sky130_ef_sc_hd__decap_12
XFILLER_0_81_306 VGND VGND VPWR VPWR sky130_fd_sc_hd__decap_4
XFILLER_0_62_531 VGND VGND VPWR VPWR sky130_fd_sc_hd__fill_1
XFILLER_0_22_417 VGND VGND VPWR VPWR sky130_fd_sc_hd__decap_3
XFILLER_0_30_483 VPWR VGND VPWR VGND sky130_ef_sc_hd__decap_12
XFILLER_0_27_27 VGND VGND VPWR VPWR sky130_fd_sc_hd__fill_1
XFILLER_0_43_15 VPWR VGND VPWR VGND sky130_ef_sc_hd__decap_12
XPHY_5 VGND VGND VPWR VPWR sky130_fd_sc_hd__decap_3
X_2790_ _0663_ net11 VGND VGND VPWR VPWR _1508_ sky130_fd_sc_hd__nand2_2
XFILLER_0_65_391 VGND VGND VPWR VPWR sky130_fd_sc_hd__fill_1
XFILLER_0_80_372 VGND VGND VPWR VPWR sky130_fd_sc_hd__decap_3
XFILLER_0_7_15 VPWR VGND VPWR VGND sky130_ef_sc_hd__decap_12
X_4460_ clknet_leaf_51_clock _0266_ VGND VGND VPWR VPWR _0009_ sky130_fd_sc_hd__dfxtp_1
X_4391_ clknet_leaf_12_clock _0205_ VGND VGND VPWR VPWR fifo1.mem\[2\]\[2\] sky130_fd_sc_hd__dfxtp_1
X_3411_ _2014_ _2016_ _1827_ VGND VGND VPWR VPWR _2017_ sky130_fd_sc_hd__a21oi_1
XFILLER_0_0_333 VGND VGND VPWR VPWR sky130_fd_sc_hd__decap_3
X_3342_ fifo3.mem\[0\]\[7\] fifo3.mem\[1\]\[7\] fifo3.mem\[2\]\[7\] fifo3.mem\[3\]\[7\]
+ _1864_ _1807_ VGND VGND VPWR VPWR _1967_ sky130_fd_sc_hd__mux4_1
XFILLER_0_68_45 VGND VGND VPWR VPWR sky130_fd_sc_hd__decap_8
XFILLER_0_0_377 VPWR VGND VPWR VGND sky130_ef_sc_hd__decap_12
XTAP_601 VGND VPWR sky130_fd_sc_hd__tapvpwrvgnd_1
XTAP_612 VGND VPWR sky130_fd_sc_hd__tapvpwrvgnd_1
XTAP_623 VGND VPWR sky130_fd_sc_hd__tapvpwrvgnd_1
XTAP_634 VGND VPWR sky130_fd_sc_hd__tapvpwrvgnd_1
X_3273_ _1830_ fifo3.mem\[10\]\[4\] _1835_ VGND VGND VPWR VPWR _1901_ sky130_fd_sc_hd__o21a_1
XTAP_645 VGND VPWR sky130_fd_sc_hd__tapvpwrvgnd_1
XTAP_656 VGND VPWR sky130_fd_sc_hd__tapvpwrvgnd_1
XTAP_667 VGND VPWR sky130_fd_sc_hd__tapvpwrvgnd_1
X_2224_ net175 _1137_ _1139_ _0925_ VGND VGND VPWR VPWR _0230_ sky130_fd_sc_hd__a22o_1
XTAP_678 VGND VPWR sky130_fd_sc_hd__tapvpwrvgnd_1
XTAP_689 VGND VPWR sky130_fd_sc_hd__tapvpwrvgnd_1
X_2155_ _1104_ _1101_ _1103_ net107 VGND VGND VPWR VPWR _0196_ sky130_fd_sc_hd__a22o_1
XFILLER_0_75_155 VGND VGND VPWR VPWR sky130_fd_sc_hd__fill_1
XFILLER_0_48_347 VPWR VGND VPWR VGND sky130_ef_sc_hd__decap_12
XFILLER_0_75_177 VGND VGND VPWR VPWR sky130_fd_sc_hd__decap_3
XFILLER_0_63_328 VGND VGND VPWR VPWR sky130_fd_sc_hd__decap_4
XFILLER_0_44_531 VGND VGND VPWR VPWR sky130_fd_sc_hd__fill_1
X_2988_ _1687_ _1690_ _1544_ VGND VGND VPWR VPWR _1691_ sky130_fd_sc_hd__o21ai_2
X_4727_ clknet_leaf_42_clock _0533_ VGND VGND VPWR VPWR net24 sky130_fd_sc_hd__dfxtp_1
XFILLER_0_16_299 VGND VGND VPWR VPWR sky130_fd_sc_hd__decap_8
X_4658_ clknet_leaf_48_clock _0464_ VGND VGND VPWR VPWR fifo3.mem\[14\]\[8\] sky130_fd_sc_hd__dfxtp_1
XFILLER_0_31_225 VGND VGND VPWR VPWR sky130_fd_sc_hd__decap_3
X_3609_ _0633_ _0640_ _0645_ _0646_ VGND VGND VPWR VPWR _0647_ sky130_fd_sc_hd__nand4b_2
XFILLER_0_12_450 VPWR VGND VPWR VGND sky130_ef_sc_hd__decap_12
X_4589_ clknet_leaf_9_clock _0395_ VGND VGND VPWR VPWR fifo1.mem\[10\]\[0\] sky130_fd_sc_hd__dfxtp_1
XFILLER_0_54_317 VPWR VGND VPWR VGND sky130_ef_sc_hd__decap_12
XFILLER_0_66_155 VGND VGND VPWR VPWR sky130_fd_sc_hd__fill_1
XFILLER_0_81_169 VGND VGND VPWR VPWR sky130_fd_sc_hd__fill_1
XFILLER_0_50_512 VGND VGND VPWR VPWR sky130_fd_sc_hd__decap_4
XFILLER_0_1_108 VGND VGND VPWR VPWR sky130_fd_sc_hd__decap_4
XFILLER_0_30_291 VPWR VGND VPWR VGND sky130_ef_sc_hd__decap_12
XFILLER_0_38_15 VPWR VGND VPWR VGND sky130_ef_sc_hd__decap_12
XFILLER_0_38_37 VGND VGND VPWR VPWR sky130_fd_sc_hd__fill_2
XFILLER_0_89_225 VGND VGND VPWR VPWR sky130_fd_sc_hd__decap_8
XFILLER_0_89_269 VGND VGND VPWR VPWR sky130_fd_sc_hd__fill_2
X_3960_ fifo1.lfd_state _0678_ _0652_ _0681_ VGND VGND VPWR VPWR _0910_ sky130_fd_sc_hd__nand4b_4
X_2911_ _1599_ _1604_ _1610_ _1615_ VGND VGND VPWR VPWR _1616_ sky130_fd_sc_hd__a22oi_4
X_3891_ _0725_ _0859_ fifo1.data_in\[3\] _0860_ VGND VGND VPWR VPWR _0864_ sky130_fd_sc_hd__and4b_1
XFILLER_0_45_317 VGND VGND VPWR VPWR sky130_fd_sc_hd__fill_1
XFILLER_0_85_497 VGND VGND VPWR VPWR sky130_fd_sc_hd__decap_6
XFILLER_0_72_147 VGND VGND VPWR VPWR sky130_fd_sc_hd__fill_1
X_2842_ fifo2.mem\[8\]\[8\] fifo2.mem\[9\]\[8\] fifo2.mem\[10\]\[8\] fifo2.mem\[11\]\[8\]
+ _1539_ _1540_ VGND VGND VPWR VPWR _1548_ sky130_fd_sc_hd__mux4_2
X_2773_ _0727_ _0853_ _1496_ VGND VGND VPWR VPWR _0422_ sky130_fd_sc_hd__o21a_1
XFILLER_0_60_309 VPWR VGND VPWR VGND sky130_ef_sc_hd__decap_12
XFILLER_0_13_225 VGND VGND VPWR VPWR sky130_fd_sc_hd__fill_1
X_4512_ clknet_leaf_33_clock _0318_ VGND VGND VPWR VPWR fifo2.mem\[9\]\[4\] sky130_fd_sc_hd__dfxtp_1
Xhold104 fifo3.mem\[14\]\[7\] VGND VGND VPWR VPWR net152 sky130_fd_sc_hd__dlygate4sd3_1
Xhold115 fifo1.mem\[9\]\[0\] VGND VGND VPWR VPWR net163 sky130_fd_sc_hd__dlygate4sd3_1
Xhold126 fifo1.mem\[14\]\[4\] VGND VGND VPWR VPWR net174 sky130_fd_sc_hd__dlygate4sd3_1
Xhold148 fifo1.mem\[14\]\[7\] VGND VGND VPWR VPWR net196 sky130_fd_sc_hd__dlygate4sd3_1
Xhold137 fifo3.mem\[5\]\[0\] VGND VGND VPWR VPWR net185 sky130_fd_sc_hd__dlygate4sd3_1
Xhold159 fifo2.mem\[9\]\[4\] VGND VGND VPWR VPWR net207 sky130_fd_sc_hd__dlygate4sd3_1
X_4443_ clknet_leaf_20_clock _0249_ VGND VGND VPWR VPWR fifo1.wr_pointer\[1\] sky130_fd_sc_hd__dfxtp_2
X_4374_ clknet_leaf_9_clock _0188_ VGND VGND VPWR VPWR fifo1.mem\[9\]\[3\] sky130_fd_sc_hd__dfxtp_1
X_3325_ fifo3.mem\[15\]\[6\] _1849_ VGND VGND VPWR VPWR _1951_ sky130_fd_sc_hd__and2b_1
XTAP_420 VGND VPWR sky130_fd_sc_hd__tapvpwrvgnd_1
XTAP_431 VGND VPWR sky130_fd_sc_hd__tapvpwrvgnd_1
XTAP_442 VGND VPWR sky130_fd_sc_hd__tapvpwrvgnd_1
X_3256_ _1846_ fifo3.mem\[14\]\[3\] _1806_ VGND VGND VPWR VPWR _1885_ sky130_fd_sc_hd__o21ai_1
XTAP_453 VGND VPWR sky130_fd_sc_hd__tapvpwrvgnd_1
XTAP_464 VGND VPWR sky130_fd_sc_hd__tapvpwrvgnd_1
XTAP_475 VGND VPWR sky130_fd_sc_hd__tapvpwrvgnd_1
XFILLER_0_28_81 VGND VGND VPWR VPWR sky130_fd_sc_hd__decap_3
XTAP_486 VGND VPWR sky130_fd_sc_hd__tapvpwrvgnd_1
XTAP_497 VGND VPWR sky130_fd_sc_hd__tapvpwrvgnd_1
X_2207_ _0760_ _1121_ _1125_ _1129_ VGND VGND VPWR VPWR _0223_ sky130_fd_sc_hd__a31o_1
X_3187_ _1817_ _1818_ _1812_ VGND VGND VPWR VPWR _1819_ sky130_fd_sc_hd__mux2_1
XFILLER_0_21_3 VPWR VGND VPWR VGND sky130_ef_sc_hd__decap_12
X_2138_ _0731_ VGND VGND VPWR VPWR _1098_ sky130_fd_sc_hd__buf_4
XFILLER_0_36_306 VGND VGND VPWR VPWR sky130_fd_sc_hd__fill_2
XFILLER_0_29_391 VGND VGND VPWR VPWR sky130_fd_sc_hd__fill_1
XFILLER_0_63_169 VGND VGND VPWR VPWR sky130_fd_sc_hd__decap_4
XFILLER_0_39_166 VGND VGND VPWR VPWR sky130_fd_sc_hd__fill_2
XFILLER_0_40_27 VGND VGND VPWR VPWR sky130_fd_sc_hd__fill_1
XFILLER_0_82_489 VPWR VGND VPWR VGND sky130_ef_sc_hd__decap_12
XFILLER_0_35_383 VGND VGND VPWR VPWR sky130_fd_sc_hd__decap_8
X_3110_ _0770_ VGND VGND VPWR VPWR _1779_ sky130_fd_sc_hd__buf_2
XFILLER_0_4_27 VGND VGND VPWR VPWR sky130_fd_sc_hd__fill_1
X_4090_ regis.header_byte\[0\] _0684_ _0994_ _0989_ VGND VGND VPWR VPWR _0995_ sky130_fd_sc_hd__o2bb2a_1
XFILLER_0_65_57 VGND VGND VPWR VPWR sky130_fd_sc_hd__decap_3
X_3041_ fifo2.count\[5\] _1619_ _1554_ _0963_ VGND VGND VPWR VPWR _1742_ sky130_fd_sc_hd__o31ai_1
XFILLER_0_85_261 VPWR VGND VPWR VGND sky130_ef_sc_hd__decap_12
X_3943_ _0895_ _0896_ _0898_ VGND VGND VPWR VPWR _0091_ sky130_fd_sc_hd__o21a_1
X_3874_ _0797_ _0825_ _0830_ _0850_ VGND VGND VPWR VPWR _0070_ sky130_fd_sc_hd__a31o_1
XFILLER_0_45_169 VGND VGND VPWR VPWR sky130_fd_sc_hd__decap_6
X_2825_ _1324_ _0983_ VGND VGND VPWR VPWR _1534_ sky130_fd_sc_hd__and2_1
XFILLER_0_73_489 VGND VGND VPWR VPWR sky130_fd_sc_hd__fill_1
XFILLER_0_60_106 VGND VGND VPWR VPWR sky130_fd_sc_hd__decap_3
X_2756_ _1107_ _1491_ _1492_ net302 VGND VGND VPWR VPWR _0409_ sky130_fd_sc_hd__a22o_1
XFILLER_0_5_277 VGND VGND VPWR VPWR sky130_fd_sc_hd__decap_3
X_2687_ _1467_ _1438_ _0962_ fifo2.mem\[2\]\[3\] _0967_ VGND VGND VPWR VPWR _1471_
+ sky130_fd_sc_hd__o311a_1
XFILLER_0_1_461 VPWR VGND VPWR VGND sky130_ef_sc_hd__decap_12
X_4426_ clknet_leaf_50_clock _0015_ VGND VGND VPWR VPWR fsm1.present_state\[1\] sky130_fd_sc_hd__dfxtp_2
XFILLER_0_69_3 VGND VGND VPWR VPWR sky130_fd_sc_hd__decap_3
X_4357_ clknet_leaf_44_clock _0171_ VGND VGND VPWR VPWR regis.packet_parity\[4\] sky130_fd_sc_hd__dfxtp_1
XTAP_250 VGND VPWR sky130_fd_sc_hd__tapvpwrvgnd_1
XTAP_283 VGND VPWR sky130_fd_sc_hd__tapvpwrvgnd_1
X_3308_ fifo3.mem\[13\]\[5\] _1804_ VGND VGND VPWR VPWR _1935_ sky130_fd_sc_hd__and2b_1
XTAP_272 VGND VPWR sky130_fd_sc_hd__tapvpwrvgnd_1
XTAP_261 VGND VPWR sky130_fd_sc_hd__tapvpwrvgnd_1
X_4288_ clknet_leaf_42_clock _0102_ VGND VGND VPWR VPWR regis.fifo_full_state\[5\]
+ sky130_fd_sc_hd__dfxtp_1
XTAP_294 VGND VPWR sky130_fd_sc_hd__tapvpwrvgnd_1
X_3239_ _1828_ fifo3.mem\[6\]\[3\] _1806_ VGND VGND VPWR VPWR _1868_ sky130_fd_sc_hd__o21ai_1
XFILLER_0_76_261 VGND VGND VPWR VPWR sky130_fd_sc_hd__fill_2
XFILLER_0_91_253 VPWR VGND VPWR VGND sky130_ef_sc_hd__decap_12
XFILLER_0_91_231 VPWR VGND VPWR VGND sky130_ef_sc_hd__decap_12
XFILLER_0_32_386 VGND VGND VPWR VPWR sky130_fd_sc_hd__decap_8
XFILLER_0_35_16 VGND VGND VPWR VPWR sky130_fd_sc_hd__fill_2
XFILLER_0_59_206 VGND VGND VPWR VPWR sky130_fd_sc_hd__decap_4
XFILLER_0_27_169 VPWR VGND VPWR VGND sky130_ef_sc_hd__decap_12
XFILLER_0_55_445 VGND VGND VPWR VPWR sky130_fd_sc_hd__decap_3
XFILLER_0_55_489 VGND VGND VPWR VPWR sky130_fd_sc_hd__fill_1
X_2610_ _0713_ _0871_ _0956_ _1441_ net182 VGND VGND VPWR VPWR _0314_ sky130_fd_sc_hd__a32o_1
X_3590_ _0624_ _0625_ _0626_ _0627_ VGND VGND VPWR VPWR _0628_ sky130_fd_sc_hd__nand4_4
X_2541_ _0833_ _1417_ _0834_ _0693_ _0799_ VGND VGND VPWR VPWR _1418_ sky130_fd_sc_hd__o311a_2
X_2472_ _1320_ fifo1.mem\[15\]\[5\] _1312_ VGND VGND VPWR VPWR _1355_ sky130_fd_sc_hd__o21bai_1
X_4211_ clknet_leaf_25_clock _0025_ VGND VGND VPWR VPWR syn.count0\[5\] sky130_fd_sc_hd__dfxtp_1
X_4142_ net5 _1027_ _0875_ _1034_ VGND VGND VPWR VPWR _0154_ sky130_fd_sc_hd__o211a_1
X_4073_ _0742_ _0723_ _0851_ VGND VGND VPWR VPWR _0982_ sky130_fd_sc_hd__and3_1
X_3024_ fifo2.mem\[4\]\[7\] fifo2.mem\[5\]\[7\] fifo2.mem\[6\]\[7\] fifo2.mem\[7\]\[7\]
+ _1557_ _1540_ VGND VGND VPWR VPWR _1725_ sky130_fd_sc_hd__mux4_1
X_3926_ _0882_ _0885_ _0886_ VGND VGND VPWR VPWR _0887_ sky130_fd_sc_hd__and3b_1
XFILLER_0_6_531 VGND VGND VPWR VPWR sky130_fd_sc_hd__fill_1
X_3857_ _0834_ VGND VGND VPWR VPWR _0841_ sky130_fd_sc_hd__buf_2
X_2808_ fifo1.mem\[12\]\[0\] fifo1.mem\[13\]\[0\] fifo1.mem\[14\]\[0\] fifo1.mem\[15\]\[0\]
+ _1317_ _1339_ VGND VGND VPWR VPWR _1522_ sky130_fd_sc_hd__mux4_1
X_3788_ _0781_ VGND VGND VPWR VPWR _0789_ sky130_fd_sc_hd__clkbuf_4
XFILLER_0_26_180 VGND VGND VPWR VPWR sky130_fd_sc_hd__decap_6
X_2739_ _1110_ _1488_ _1489_ net201 VGND VGND VPWR VPWR _0395_ sky130_fd_sc_hd__a22o_1
X_4409_ clknet_leaf_19_clock _0223_ VGND VGND VPWR VPWR fifo1.mem\[7\]\[2\] sky130_fd_sc_hd__dfxtp_1
XFILLER_0_5_81 VGND VGND VPWR VPWR sky130_fd_sc_hd__decap_6
XFILLER_0_37_434 VGND VGND VPWR VPWR sky130_fd_sc_hd__fill_1
XFILLER_0_9_391 VGND VGND VPWR VPWR sky130_fd_sc_hd__fill_1
XFILLER_0_24_106 VGND VGND VPWR VPWR sky130_fd_sc_hd__fill_1
XFILLER_0_52_448 VGND VGND VPWR VPWR sky130_fd_sc_hd__decap_4
XFILLER_0_20_301 VGND VGND VPWR VPWR sky130_fd_sc_hd__decap_6
XFILLER_0_46_15 VPWR VGND VPWR VGND sky130_ef_sc_hd__decap_12
XFILLER_0_1_39 VPWR VGND VPWR VGND sky130_ef_sc_hd__decap_12
XFILLER_0_62_36 VGND VGND VPWR VPWR sky130_fd_sc_hd__decap_8
XFILLER_0_75_529 VPWR VGND VPWR VGND sky130_ef_sc_hd__decap_12
XFILLER_0_28_445 VGND VGND VPWR VPWR sky130_fd_sc_hd__decap_4
X_4760_ clknet_leaf_41_clock _0566_ VGND VGND VPWR VPWR fifo2.mem\[11\]\[6\] sky130_fd_sc_hd__dfxtp_1
X_4691_ clknet_leaf_17_clock _0497_ VGND VGND VPWR VPWR fifo1.mem\[15\]\[1\] sky130_fd_sc_hd__dfxtp_1
X_3711_ fifo1.data_in\[1\] VGND VGND VPWR VPWR _0731_ sky130_fd_sc_hd__buf_4
XFILLER_0_28_489 VPWR VGND VPWR VGND sky130_ef_sc_hd__decap_12
XFILLER_0_15_139 VGND VGND VPWR VPWR sky130_fd_sc_hd__decap_3
X_3642_ _0676_ VGND VGND VPWR VPWR _0016_ sky130_fd_sc_hd__clkbuf_1
X_3573_ fifo1.rd_pointer\[0\] fifo1.wr_pointer\[0\] VGND VGND VPWR VPWR _0612_ sky130_fd_sc_hd__and2_1
XFILLER_0_87_55 VGND VGND VPWR VPWR sky130_fd_sc_hd__fill_1
X_2524_ _0637_ _1404_ _1005_ VGND VGND VPWR VPWR _1405_ sky130_fd_sc_hd__o21ai_1
XFILLER_0_11_389 VGND VGND VPWR VPWR sky130_fd_sc_hd__decap_3
X_2455_ _1178_ VGND VGND VPWR VPWR _1339_ sky130_fd_sc_hd__buf_4
Xhold19 fifo3.mem\[0\]\[1\] VGND VGND VPWR VPWR net67 sky130_fd_sc_hd__dlygate4sd3_1
X_2386_ _1220_ fifo1.mem\[9\]\[4\] _1271_ VGND VGND VPWR VPWR _1272_ sky130_fd_sc_hd__o21ai_2
X_4125_ net8 _0986_ _0989_ _1022_ VGND VGND VPWR VPWR _1023_ sky130_fd_sc_hd__o211ai_1
X_4056_ _0619_ _0726_ _0727_ VGND VGND VPWR VPWR _0971_ sky130_fd_sc_hd__nor3_1
X_3007_ fifo2.mem\[3\]\[6\] _1582_ _1708_ VGND VGND VPWR VPWR _1709_ sky130_fd_sc_hd__o21ai_1
X_3909_ _0656_ fsm1.addr\[0\] VGND VGND VPWR VPWR _0876_ sky130_fd_sc_hd__or2_1
XFILLER_0_46_253 VPWR VGND VPWR VGND sky130_ef_sc_hd__decap_12
XFILLER_0_61_245 VGND VGND VPWR VPWR sky130_fd_sc_hd__fill_2
XFILLER_0_61_267 VGND VGND VPWR VPWR sky130_fd_sc_hd__decap_6
XFILLER_0_14_194 VGND VGND VPWR VPWR sky130_fd_sc_hd__fill_2
XFILLER_0_88_109 VPWR VGND VPWR VGND sky130_ef_sc_hd__decap_12
XTAP_1021 VGND VPWR sky130_fd_sc_hd__tapvpwrvgnd_1
XTAP_1010 VGND VPWR sky130_fd_sc_hd__tapvpwrvgnd_1
XTAP_1065 VGND VPWR sky130_fd_sc_hd__tapvpwrvgnd_1
XTAP_1054 VGND VPWR sky130_fd_sc_hd__tapvpwrvgnd_1
XTAP_1043 VGND VPWR sky130_fd_sc_hd__tapvpwrvgnd_1
XTAP_1032 VGND VPWR sky130_fd_sc_hd__tapvpwrvgnd_1
XFILLER_0_69_389 VGND VGND VPWR VPWR sky130_fd_sc_hd__decap_3
XTAP_1076 VGND VPWR sky130_fd_sc_hd__tapvpwrvgnd_1
XTAP_805 VGND VPWR sky130_fd_sc_hd__tapvpwrvgnd_1
XTAP_816 VGND VPWR sky130_fd_sc_hd__tapvpwrvgnd_1
XTAP_827 VGND VPWR sky130_fd_sc_hd__tapvpwrvgnd_1
XTAP_838 VGND VPWR sky130_fd_sc_hd__tapvpwrvgnd_1
XTAP_849 VGND VPWR sky130_fd_sc_hd__tapvpwrvgnd_1
X_2240_ _1104_ _1141_ _1144_ net274 VGND VGND VPWR VPWR _0241_ sky130_fd_sc_hd__a22o_1
X_2171_ _1113_ VGND VGND VPWR VPWR _1114_ sky130_fd_sc_hd__clkbuf_4
Xclkbuf_leaf_7_clock clknet_3_2__leaf_clock VGND VGND VPWR VPWR clknet_leaf_7_clock
+ sky130_fd_sc_hd__clkbuf_16
XFILLER_0_73_57 VGND VGND VPWR VPWR sky130_fd_sc_hd__decap_8
XFILLER_0_48_529 VGND VGND VPWR VPWR sky130_fd_sc_hd__decap_3
XFILLER_0_7_103 VGND VGND VPWR VPWR sky130_fd_sc_hd__decap_8
XFILLER_0_28_242 VGND VGND VPWR VPWR sky130_fd_sc_hd__decap_8
XFILLER_0_90_307 VGND VGND VPWR VPWR sky130_fd_sc_hd__fill_1
X_4743_ clknet_leaf_20_clock _0549_ VGND VGND VPWR VPWR _0002_ sky130_fd_sc_hd__dfxtp_4
XFILLER_0_7_169 VGND VGND VPWR VPWR sky130_fd_sc_hd__decap_6
XFILLER_0_43_223 VGND VGND VPWR VPWR sky130_fd_sc_hd__fill_1
X_4674_ clknet_leaf_59_clock _0480_ VGND VGND VPWR VPWR fifo3.mem\[9\]\[6\] sky130_fd_sc_hd__dfxtp_1
XFILLER_0_43_256 VGND VGND VPWR VPWR sky130_fd_sc_hd__fill_2
XFILLER_0_24_470 VGND VGND VPWR VPWR sky130_fd_sc_hd__decap_6
X_3625_ _0624_ _0625_ _0626_ _0662_ VGND VGND VPWR VPWR _0663_ sky130_fd_sc_hd__nand4_2
X_3556_ _0803_ _0919_ _0921_ VGND VGND VPWR VPWR _2106_ sky130_fd_sc_hd__a21oi_4
X_2507_ _1199_ _1202_ _1387_ _1389_ VGND VGND VPWR VPWR _1390_ sky130_fd_sc_hd__o211ai_1
X_3487_ _2072_ _0783_ net341 _2077_ VGND VGND VPWR VPWR _0555_ sky130_fd_sc_hd__a31o_1
XFILLER_0_51_3 VGND VGND VPWR VPWR sky130_fd_sc_hd__fill_2
X_2438_ _1319_ _1322_ _1175_ VGND VGND VPWR VPWR _1323_ sky130_fd_sc_hd__o21ai_1
X_2369_ _1239_ _1244_ _1249_ _1255_ VGND VGND VPWR VPWR _1256_ sky130_fd_sc_hd__a22oi_4
X_4108_ _1007_ _1009_ _1005_ VGND VGND VPWR VPWR _0145_ sky130_fd_sc_hd__a21boi_1
X_4039_ _0716_ VGND VGND VPWR VPWR _0961_ sky130_fd_sc_hd__clkbuf_4
XFILLER_0_2_82 VGND VGND VPWR VPWR sky130_fd_sc_hd__fill_2
XFILLER_0_78_197 VGND VGND VPWR VPWR sky130_fd_sc_hd__fill_2
XFILLER_0_39_529 VPWR VGND VPWR VGND sky130_ef_sc_hd__decap_12
XPHY_104 VGND VGND VPWR VPWR sky130_fd_sc_hd__decap_3
XPHY_115 VGND VGND VPWR VPWR sky130_fd_sc_hd__decap_3
XPHY_148 VGND VGND VPWR VPWR sky130_fd_sc_hd__decap_3
XFILLER_0_19_220 VGND VGND VPWR VPWR sky130_fd_sc_hd__decap_4
XPHY_126 VGND VGND VPWR VPWR sky130_fd_sc_hd__decap_3
XFILLER_0_66_348 VGND VGND VPWR VPWR sky130_fd_sc_hd__decap_3
XFILLER_0_66_359 VGND VGND VPWR VPWR sky130_fd_sc_hd__decap_4
XPHY_137 VGND VGND VPWR VPWR sky130_fd_sc_hd__decap_3
XFILLER_0_81_329 VGND VGND VPWR VPWR sky130_fd_sc_hd__decap_6
XPHY_159 VGND VGND VPWR VPWR sky130_fd_sc_hd__decap_3
XFILLER_0_34_223 VGND VGND VPWR VPWR sky130_fd_sc_hd__fill_2
XFILLER_0_34_245 VGND VGND VPWR VPWR sky130_fd_sc_hd__decap_6
XFILLER_0_30_495 VPWR VGND VPWR VGND sky130_ef_sc_hd__decap_12
XFILLER_0_69_120 VGND VGND VPWR VPWR sky130_fd_sc_hd__decap_8
XFILLER_0_43_27 VPWR VGND VPWR VGND sky130_ef_sc_hd__decap_12
XPHY_6 VGND VGND VPWR VPWR sky130_fd_sc_hd__decap_3
XFILLER_0_57_359 VGND VGND VPWR VPWR sky130_fd_sc_hd__fill_1
XFILLER_0_4_139 VGND VGND VPWR VPWR sky130_fd_sc_hd__fill_1
XFILLER_0_13_418 VPWR VGND VPWR VGND sky130_ef_sc_hd__decap_12
XFILLER_0_7_27 VPWR VGND VPWR VGND sky130_ef_sc_hd__decap_12
X_4390_ clknet_leaf_13_clock _0204_ VGND VGND VPWR VPWR fifo1.mem\[2\]\[1\] sky130_fd_sc_hd__dfxtp_1
XFILLER_0_0_301 VGND VGND VPWR VPWR sky130_fd_sc_hd__decap_3
X_3410_ fifo3.mem\[3\]\[8\] _1942_ _2015_ VGND VGND VPWR VPWR _2016_ sky130_fd_sc_hd__o21ai_1
XFILLER_0_40_259 VGND VGND VPWR VPWR sky130_fd_sc_hd__fill_1
X_3341_ _1965_ _1809_ _1814_ VGND VGND VPWR VPWR _1966_ sky130_fd_sc_hd__a21oi_2
XFILLER_0_0_389 VGND VGND VPWR VPWR sky130_fd_sc_hd__decap_3
XTAP_602 VGND VPWR sky130_fd_sc_hd__tapvpwrvgnd_1
XTAP_613 VGND VPWR sky130_fd_sc_hd__tapvpwrvgnd_1
XTAP_624 VGND VPWR sky130_fd_sc_hd__tapvpwrvgnd_1
X_3272_ _1838_ fifo3.mem\[9\]\[4\] _1899_ VGND VGND VPWR VPWR _1900_ sky130_fd_sc_hd__o21ai_1
XTAP_635 VGND VPWR sky130_fd_sc_hd__tapvpwrvgnd_1
XTAP_646 VGND VPWR sky130_fd_sc_hd__tapvpwrvgnd_1
XTAP_657 VGND VPWR sky130_fd_sc_hd__tapvpwrvgnd_1
XTAP_668 VGND VPWR sky130_fd_sc_hd__tapvpwrvgnd_1
XTAP_679 VGND VPWR sky130_fd_sc_hd__tapvpwrvgnd_1
X_2223_ _1138_ VGND VGND VPWR VPWR _1139_ sky130_fd_sc_hd__buf_2
X_2154_ _0733_ VGND VGND VPWR VPWR _1104_ sky130_fd_sc_hd__clkbuf_4
XFILLER_0_48_304 VGND VGND VPWR VPWR sky130_fd_sc_hd__decap_4
XFILLER_0_48_326 VGND VGND VPWR VPWR sky130_fd_sc_hd__decap_4
XFILLER_0_48_359 VGND VGND VPWR VPWR sky130_fd_sc_hd__decap_4
XFILLER_0_8_445 VGND VGND VPWR VPWR sky130_fd_sc_hd__decap_8
XFILLER_0_16_223 VGND VGND VPWR VPWR sky130_fd_sc_hd__fill_1
X_2987_ _1688_ _1557_ _1689_ VGND VGND VPWR VPWR _1690_ sky130_fd_sc_hd__a21oi_1
X_4726_ clknet_leaf_29_clock _0532_ VGND VGND VPWR VPWR net23 sky130_fd_sc_hd__dfxtp_1
X_4657_ clknet_leaf_49_clock _0463_ VGND VGND VPWR VPWR fifo3.mem\[14\]\[7\] sky130_fd_sc_hd__dfxtp_1
X_3608_ fsm1.addr\[0\] fsm1.addr\[1\] VGND VGND VPWR VPWR _0646_ sky130_fd_sc_hd__and2b_1
X_4588_ clknet_leaf_8_clock _0394_ VGND VGND VPWR VPWR fifo1.mem\[11\]\[8\] sky130_fd_sc_hd__dfxtp_1
X_3539_ _0936_ _2094_ _2100_ VGND VGND VPWR VPWR _0584_ sky130_fd_sc_hd__a21bo_1
XFILLER_0_79_473 VPWR VGND VPWR VGND sky130_ef_sc_hd__decap_12
XFILLER_0_81_137 VGND VGND VPWR VPWR sky130_fd_sc_hd__decap_4
XFILLER_0_54_329 VPWR VGND VPWR VGND sky130_ef_sc_hd__decap_12
XFILLER_0_38_27 VGND VGND VPWR VPWR sky130_fd_sc_hd__fill_1
X_2910_ _1612_ _1614_ _0006_ VGND VGND VPWR VPWR _1615_ sky130_fd_sc_hd__a21o_1
X_3890_ _0855_ _0856_ fifo2.mem\[8\]\[2\] _0857_ _0863_ VGND VGND VPWR VPWR _0073_
+ sky130_fd_sc_hd__a32o_1
XFILLER_0_57_167 VGND VGND VPWR VPWR sky130_fd_sc_hd__fill_1
Xclkbuf_leaf_10_clock clknet_3_2__leaf_clock VGND VGND VPWR VPWR clknet_leaf_10_clock
+ sky130_fd_sc_hd__clkbuf_16
X_2841_ _1544_ VGND VGND VPWR VPWR _1547_ sky130_fd_sc_hd__clkbuf_4
XFILLER_0_57_189 VGND VGND VPWR VPWR sky130_fd_sc_hd__fill_1
X_2772_ _0727_ _0853_ _0974_ VGND VGND VPWR VPWR _1496_ sky130_fd_sc_hd__a21oi_1
XFILLER_0_79_34 VGND VGND VPWR VPWR sky130_fd_sc_hd__decap_4
XFILLER_0_41_513 VPWR VGND VPWR VGND sky130_ef_sc_hd__decap_12
X_4511_ clknet_leaf_33_clock _0317_ VGND VGND VPWR VPWR fifo2.mem\[9\]\[3\] sky130_fd_sc_hd__dfxtp_1
Xclkbuf_leaf_25_clock clknet_3_6__leaf_clock VGND VGND VPWR VPWR clknet_leaf_25_clock
+ sky130_fd_sc_hd__clkbuf_16
Xhold105 fifo2.mem\[13\]\[6\] VGND VGND VPWR VPWR net153 sky130_fd_sc_hd__dlygate4sd3_1
Xhold116 fifo1.mem\[8\]\[5\] VGND VGND VPWR VPWR net164 sky130_fd_sc_hd__dlygate4sd3_1
X_4442_ clknet_leaf_20_clock _0248_ VGND VGND VPWR VPWR fifo1.wr_pointer\[0\] sky130_fd_sc_hd__dfxtp_1
Xhold149 fifo1.mem\[2\]\[2\] VGND VGND VPWR VPWR net197 sky130_fd_sc_hd__dlygate4sd3_1
Xhold127 fifo1.mem\[6\]\[0\] VGND VGND VPWR VPWR net175 sky130_fd_sc_hd__dlygate4sd3_1
Xhold138 fifo2.mem\[12\]\[4\] VGND VGND VPWR VPWR net186 sky130_fd_sc_hd__dlygate4sd3_1
XFILLER_0_21_281 VGND VGND VPWR VPWR sky130_fd_sc_hd__decap_8
X_4373_ clknet_leaf_9_clock _0187_ VGND VGND VPWR VPWR fifo1.mem\[9\]\[2\] sky130_fd_sc_hd__dfxtp_1
X_3324_ _1832_ fifo3.mem\[14\]\[6\] _1893_ VGND VGND VPWR VPWR _1950_ sky130_fd_sc_hd__o21ai_1
XFILLER_0_0_197 VGND VGND VPWR VPWR sky130_fd_sc_hd__fill_2
XTAP_410 VGND VPWR sky130_fd_sc_hd__tapvpwrvgnd_1
XTAP_421 VGND VPWR sky130_fd_sc_hd__tapvpwrvgnd_1
XTAP_432 VGND VPWR sky130_fd_sc_hd__tapvpwrvgnd_1
X_3255_ fifo3.mem\[15\]\[3\] VGND VGND VPWR VPWR _1884_ sky130_fd_sc_hd__inv_2
XTAP_443 VGND VPWR sky130_fd_sc_hd__tapvpwrvgnd_1
XTAP_454 VGND VPWR sky130_fd_sc_hd__tapvpwrvgnd_1
XTAP_465 VGND VPWR sky130_fd_sc_hd__tapvpwrvgnd_1
XTAP_476 VGND VPWR sky130_fd_sc_hd__tapvpwrvgnd_1
XTAP_487 VGND VPWR sky130_fd_sc_hd__tapvpwrvgnd_1
XTAP_498 VGND VPWR sky130_fd_sc_hd__tapvpwrvgnd_1
X_2206_ _1126_ _1120_ fifo1.mem\[7\]\[2\] VGND VGND VPWR VPWR _1129_ sky130_fd_sc_hd__and3_1
X_3186_ fifo3.mem\[8\]\[0\] fifo3.mem\[9\]\[0\] fifo3.mem\[10\]\[0\] fifo3.mem\[11\]\[0\]
+ _1805_ _1807_ VGND VGND VPWR VPWR _1818_ sky130_fd_sc_hd__mux4_1
XFILLER_0_14_3 VPWR VGND VPWR VGND sky130_ef_sc_hd__decap_12
X_2137_ _0747_ _1096_ _1097_ net163 VGND VGND VPWR VPWR _0185_ sky130_fd_sc_hd__a22o_1
XFILLER_0_88_270 VGND VGND VPWR VPWR sky130_fd_sc_hd__decap_3
XFILLER_0_88_292 VPWR VGND VPWR VGND sky130_ef_sc_hd__decap_12
XFILLER_0_63_159 VGND VGND VPWR VPWR sky130_fd_sc_hd__decap_3
X_4709_ clknet_leaf_45_clock _0515_ VGND VGND VPWR VPWR net32 sky130_fd_sc_hd__dfxtp_1
XFILLER_0_32_513 VPWR VGND VPWR VGND sky130_ef_sc_hd__decap_12
XFILLER_0_12_281 VGND VGND VPWR VPWR sky130_fd_sc_hd__decap_4
XFILLER_0_24_29 VGND VGND VPWR VPWR sky130_fd_sc_hd__fill_2
XFILLER_0_79_281 VPWR VGND VPWR VGND sky130_ef_sc_hd__decap_12
XFILLER_0_67_421 VGND VGND VPWR VPWR sky130_fd_sc_hd__decap_4
XFILLER_0_82_446 VPWR VGND VPWR VGND sky130_ef_sc_hd__decap_12
XFILLER_0_54_137 VGND VGND VPWR VPWR sky130_fd_sc_hd__decap_3
XFILLER_0_50_365 VGND VGND VPWR VPWR sky130_fd_sc_hd__decap_3
XFILLER_0_10_229 VPWR VGND VPWR VGND sky130_ef_sc_hd__decap_12
XFILLER_0_50_387 VGND VGND VPWR VPWR sky130_fd_sc_hd__decap_6
X_3040_ _1619_ _1739_ _1740_ _1553_ VGND VGND VPWR VPWR _1741_ sky130_fd_sc_hd__a31o_1
X_3942_ syn.count2\[3\] syn.count2\[2\] _0897_ _0894_ VGND VGND VPWR VPWR _0898_ sky130_fd_sc_hd__a31oi_4
XFILLER_0_18_307 VGND VGND VPWR VPWR sky130_fd_sc_hd__fill_1
XFILLER_0_85_273 VGND VGND VPWR VPWR sky130_fd_sc_hd__decap_6
X_3873_ _0832_ _0840_ _0841_ _0844_ fifo3.mem\[1\]\[8\] VGND VGND VPWR VPWR _0850_
+ sky130_fd_sc_hd__o311a_1
X_2824_ _1533_ VGND VGND VPWR VPWR _0436_ sky130_fd_sc_hd__buf_1
XFILLER_0_5_223 VGND VGND VPWR VPWR sky130_fd_sc_hd__fill_1
XFILLER_0_30_72 VPWR VGND VPWR VGND sky130_ef_sc_hd__decap_12
XFILLER_0_53_192 VGND VGND VPWR VPWR sky130_fd_sc_hd__fill_1
X_2755_ _1106_ _1491_ _1492_ net232 VGND VGND VPWR VPWR _0408_ sky130_fd_sc_hd__a22o_1
X_2686_ _0760_ _0960_ _1436_ _1470_ VGND VGND VPWR VPWR _0361_ sky130_fd_sc_hd__a31o_1
X_4425_ clknet_leaf_50_clock _0014_ VGND VGND VPWR VPWR fsm1.detect_add sky130_fd_sc_hd__dfxtp_2
X_4356_ clknet_leaf_44_clock _0170_ VGND VGND VPWR VPWR regis.packet_parity\[3\] sky130_fd_sc_hd__dfxtp_1
XFILLER_0_1_473 VPWR VGND VPWR VGND sky130_ef_sc_hd__decap_12
X_3307_ _1930_ _1931_ _1932_ _1933_ VGND VGND VPWR VPWR _1934_ sky130_fd_sc_hd__o22a_1
XTAP_251 VGND VPWR sky130_fd_sc_hd__tapvpwrvgnd_1
XTAP_240 VGND VPWR sky130_fd_sc_hd__tapvpwrvgnd_1
XTAP_284 VGND VPWR sky130_fd_sc_hd__tapvpwrvgnd_1
XTAP_273 VGND VPWR sky130_fd_sc_hd__tapvpwrvgnd_1
XTAP_262 VGND VPWR sky130_fd_sc_hd__tapvpwrvgnd_1
X_4287_ clknet_leaf_43_clock _0101_ VGND VGND VPWR VPWR regis.fifo_full_state\[4\]
+ sky130_fd_sc_hd__dfxtp_1
XTAP_295 VGND VPWR sky130_fd_sc_hd__tapvpwrvgnd_1
X_3238_ fifo3.mem\[7\]\[3\] VGND VGND VPWR VPWR _1867_ sky130_fd_sc_hd__inv_2
X_3169_ net251 _1801_ _1803_ _0764_ VGND VGND VPWR VPWR _0511_ sky130_fd_sc_hd__a22o_1
XFILLER_0_76_251 VGND VGND VPWR VPWR sky130_fd_sc_hd__fill_1
XFILLER_0_91_221 VGND VGND VPWR VPWR sky130_fd_sc_hd__decap_3
XFILLER_0_49_498 VGND VGND VPWR VPWR sky130_fd_sc_hd__decap_6
XFILLER_0_64_435 VGND VGND VPWR VPWR sky130_fd_sc_hd__decap_6
XFILLER_0_91_243 VGND VGND VPWR VPWR sky130_fd_sc_hd__decap_8
XFILLER_0_36_159 VGND VGND VPWR VPWR sky130_fd_sc_hd__fill_1
XFILLER_0_64_457 VGND VGND VPWR VPWR sky130_fd_sc_hd__decap_4
XFILLER_0_91_265 VGND VGND VPWR VPWR sky130_fd_sc_hd__fill_2
XFILLER_0_51_118 VGND VGND VPWR VPWR sky130_fd_sc_hd__fill_1
XFILLER_0_32_365 VGND VGND VPWR VPWR sky130_fd_sc_hd__decap_4
XFILLER_0_3_3 VPWR VGND VPWR VGND sky130_ef_sc_hd__decap_12
XFILLER_0_87_505 VPWR VGND VPWR VGND sky130_ef_sc_hd__decap_12
XFILLER_0_27_137 VPWR VGND VPWR VGND sky130_ef_sc_hd__decap_12
XFILLER_0_35_181 VGND VGND VPWR VPWR sky130_fd_sc_hd__decap_3
XFILLER_0_63_490 VPWR VGND VPWR VGND sky130_ef_sc_hd__decap_12
XFILLER_0_70_449 VGND VGND VPWR VPWR sky130_fd_sc_hd__decap_4
XFILLER_0_11_505 VPWR VGND VPWR VGND sky130_ef_sc_hd__decap_12
X_2540_ _0823_ _0831_ VGND VGND VPWR VPWR _1417_ sky130_fd_sc_hd__nand2_1
X_2471_ _1181_ _1352_ _1353_ _1256_ VGND VGND VPWR VPWR _1354_ sky130_fd_sc_hd__o211a_1
X_4210_ clknet_leaf_25_clock _0024_ VGND VGND VPWR VPWR syn.count0\[4\] sky130_fd_sc_hd__dfxtp_1
XFILLER_0_76_24 VGND VGND VPWR VPWR sky130_fd_sc_hd__decap_4
X_4141_ _1026_ _0680_ _0656_ regis.header_byte\[4\] VGND VGND VPWR VPWR _1034_ sky130_fd_sc_hd__a31o_1
X_4072_ _0729_ VGND VGND VPWR VPWR _0981_ sky130_fd_sc_hd__clkbuf_4
X_3023_ _1629_ _1632_ VGND VGND VPWR VPWR _1724_ sky130_fd_sc_hd__nor2_1
X_3925_ syn.count1\[3\] _0884_ VGND VGND VPWR VPWR _0886_ sky130_fd_sc_hd__nand2_1
XFILLER_0_46_435 VGND VGND VPWR VPWR sky130_fd_sc_hd__fill_1
XFILLER_0_46_468 VGND VGND VPWR VPWR sky130_fd_sc_hd__fill_2
XFILLER_0_73_276 VGND VGND VPWR VPWR sky130_fd_sc_hd__decap_4
X_3856_ _0770_ VGND VGND VPWR VPWR _0840_ sky130_fd_sc_hd__clkbuf_4
XFILLER_0_81_3 VPWR VGND VPWR VGND sky130_ef_sc_hd__decap_12
X_2807_ _1187_ _1520_ _1181_ VGND VGND VPWR VPWR _1521_ sky130_fd_sc_hd__a21o_1
X_3787_ _0759_ _0778_ _0783_ _0788_ VGND VGND VPWR VPWR _0045_ sky130_fd_sc_hd__a31o_1
X_2738_ _1102_ _1488_ VGND VGND VPWR VPWR _1489_ sky130_fd_sc_hd__nor2_4
XFILLER_0_14_376 VGND VGND VPWR VPWR sky130_fd_sc_hd__decap_8
X_4408_ clknet_leaf_6_clock _0222_ VGND VGND VPWR VPWR fifo1.mem\[7\]\[1\] sky130_fd_sc_hd__dfxtp_1
X_2669_ _1464_ VGND VGND VPWR VPWR _1465_ sky130_fd_sc_hd__clkbuf_4
X_4339_ clknet_leaf_43_clock _0153_ VGND VGND VPWR VPWR regis.header_byte\[3\] sky130_fd_sc_hd__dfxtp_1
XFILLER_0_5_93 VGND VGND VPWR VPWR sky130_fd_sc_hd__decap_4
XFILLER_0_69_505 VGND VGND VPWR VPWR sky130_fd_sc_hd__decap_8
XFILLER_0_37_424 VGND VGND VPWR VPWR sky130_fd_sc_hd__fill_2
XFILLER_0_37_457 VPWR VGND VPWR VGND sky130_ef_sc_hd__decap_12
XFILLER_0_46_27 VGND VGND VPWR VPWR sky130_fd_sc_hd__fill_1
XFILLER_0_87_335 VGND VGND VPWR VPWR sky130_fd_sc_hd__fill_1
X_3710_ _0713_ _0715_ _0724_ _0730_ net114 VGND VGND VPWR VPWR _0026_ sky130_fd_sc_hd__a32o_1
XFILLER_0_7_307 VGND VGND VPWR VPWR sky130_fd_sc_hd__decap_3
XFILLER_0_55_221 VGND VGND VPWR VPWR sky130_fd_sc_hd__decap_3
XFILLER_0_55_243 VGND VGND VPWR VPWR sky130_fd_sc_hd__fill_2
X_4690_ clknet_leaf_17_clock _0496_ VGND VGND VPWR VPWR fifo1.mem\[15\]\[0\] sky130_fd_sc_hd__dfxtp_1
X_3641_ _0675_ _0654_ VGND VGND VPWR VPWR _0676_ sky130_fd_sc_hd__and2_1
XFILLER_0_43_449 VGND VGND VPWR VPWR sky130_fd_sc_hd__decap_8
X_3572_ fifo1.rd_pointer\[0\] fifo1.wr_pointer\[0\] VGND VGND VPWR VPWR _0611_ sky130_fd_sc_hd__nor2_1
X_2523_ _1403_ VGND VGND VPWR VPWR _1404_ sky130_fd_sc_hd__clkbuf_2
XFILLER_0_51_471 VGND VGND VPWR VPWR sky130_fd_sc_hd__decap_6
X_2454_ fifo1.mem\[10\]\[6\] fifo1.mem\[11\]\[6\] _1189_ VGND VGND VPWR VPWR _1338_
+ sky130_fd_sc_hd__mux2_1
X_2385_ _1232_ fifo1.mem\[8\]\[4\] _1182_ VGND VGND VPWR VPWR _1271_ sky130_fd_sc_hd__o21ba_1
X_4124_ regis.fifo_full_state\[7\] _0990_ _0690_ VGND VGND VPWR VPWR _1022_ sky130_fd_sc_hd__o21ba_1
Xinput1 data_in[0] VGND VGND VPWR VPWR net1 sky130_fd_sc_hd__clkbuf_2
X_4055_ _0797_ _0960_ _0956_ _0970_ VGND VGND VPWR VPWR _0131_ sky130_fd_sc_hd__a31o_1
XFILLER_0_36_82 VGND VGND VPWR VPWR sky130_fd_sc_hd__fill_2
X_3006_ _1569_ fifo2.mem\[2\]\[6\] _1540_ VGND VGND VPWR VPWR _1708_ sky130_fd_sc_hd__o21a_1
XFILLER_0_19_435 VGND VGND VPWR VPWR sky130_fd_sc_hd__decap_3
XFILLER_0_52_81 VGND VGND VPWR VPWR sky130_fd_sc_hd__decap_3
X_3908_ _0874_ VGND VGND VPWR VPWR _0875_ sky130_fd_sc_hd__buf_4
XFILLER_0_46_265 VGND VGND VPWR VPWR sky130_fd_sc_hd__fill_2
XFILLER_0_6_362 VGND VGND VPWR VPWR sky130_fd_sc_hd__fill_2
X_3839_ _0823_ fifo3.wr_pointer\[0\] VGND VGND VPWR VPWR _0824_ sky130_fd_sc_hd__and2b_1
XFILLER_0_42_493 VGND VGND VPWR VPWR sky130_fd_sc_hd__fill_1
XFILLER_0_69_324 VPWR VGND VPWR VGND sky130_ef_sc_hd__decap_12
XTAP_1022 VGND VPWR sky130_fd_sc_hd__tapvpwrvgnd_1
XTAP_1011 VGND VPWR sky130_fd_sc_hd__tapvpwrvgnd_1
XTAP_1000 VGND VPWR sky130_fd_sc_hd__tapvpwrvgnd_1
XTAP_1055 VGND VPWR sky130_fd_sc_hd__tapvpwrvgnd_1
XTAP_1044 VGND VPWR sky130_fd_sc_hd__tapvpwrvgnd_1
XTAP_1033 VGND VPWR sky130_fd_sc_hd__tapvpwrvgnd_1
XFILLER_0_32_29 VGND VGND VPWR VPWR sky130_fd_sc_hd__decap_6
XTAP_1066 VGND VPWR sky130_fd_sc_hd__tapvpwrvgnd_1
XFILLER_0_80_533 VGND VGND VPWR VPWR sky130_fd_sc_hd__decap_8
XFILLER_0_25_449 VPWR VGND VPWR VGND sky130_ef_sc_hd__decap_12
XFILLER_0_52_235 VPWR VGND VPWR VGND sky130_ef_sc_hd__decap_12
XFILLER_0_40_419 VGND VGND VPWR VPWR sky130_fd_sc_hd__fill_1
XFILLER_0_0_505 VGND VGND VPWR VPWR sky130_fd_sc_hd__decap_8
XFILLER_0_20_121 VGND VGND VPWR VPWR sky130_fd_sc_hd__decap_3
XFILLER_0_20_176 VPWR VGND VPWR VGND sky130_ef_sc_hd__decap_12
XTAP_806 VGND VPWR sky130_fd_sc_hd__tapvpwrvgnd_1
XTAP_817 VGND VPWR sky130_fd_sc_hd__tapvpwrvgnd_1
XTAP_828 VGND VPWR sky130_fd_sc_hd__tapvpwrvgnd_1
XTAP_839 VGND VPWR sky130_fd_sc_hd__tapvpwrvgnd_1
X_2170_ _0750_ _0751_ _1111_ _1112_ VGND VGND VPWR VPWR _1113_ sky130_fd_sc_hd__and4_1
XFILLER_0_87_110 VGND VGND VPWR VPWR sky130_fd_sc_hd__fill_2
XFILLER_0_71_500 VGND VGND VPWR VPWR sky130_fd_sc_hd__decap_4
X_4742_ clknet_leaf_18_clock _0548_ VGND VGND VPWR VPWR _0001_ sky130_fd_sc_hd__dfxtp_1
XFILLER_0_83_393 VPWR VGND VPWR VGND sky130_ef_sc_hd__decap_12
XFILLER_0_7_159 VGND VGND VPWR VPWR sky130_fd_sc_hd__decap_8
X_4673_ clknet_leaf_60_clock _0479_ VGND VGND VPWR VPWR fifo3.mem\[9\]\[5\] sky130_fd_sc_hd__dfxtp_1
XFILLER_0_28_298 VGND VGND VPWR VPWR sky130_fd_sc_hd__decap_8
XFILLER_0_43_235 VGND VGND VPWR VPWR sky130_fd_sc_hd__decap_4
XFILLER_0_31_408 VGND VGND VPWR VPWR sky130_fd_sc_hd__fill_1
X_3624_ fifo2.rd_pointer\[4\] fifo2.wr_pointer\[4\] VGND VGND VPWR VPWR _0662_ sky130_fd_sc_hd__xnor2_1
XFILLER_0_3_332 VGND VGND VPWR VPWR sky130_fd_sc_hd__decap_4
X_3555_ _0767_ _2105_ _2103_ _2104_ net134 VGND VGND VPWR VPWR _0595_ sky130_fd_sc_hd__a32o_1
X_2506_ _1388_ _1385_ _1349_ _1325_ VGND VGND VPWR VPWR _1389_ sky130_fd_sc_hd__o22ai_1
X_3486_ _0737_ _2070_ net46 VGND VGND VPWR VPWR _2077_ sky130_fd_sc_hd__and3_1
XFILLER_0_11_198 VGND VGND VPWR VPWR sky130_fd_sc_hd__fill_2
X_2437_ _1320_ fifo1.mem\[11\]\[5\] _1321_ VGND VGND VPWR VPWR _1322_ sky130_fd_sc_hd__o21a_1
XFILLER_0_44_3 VPWR VGND VPWR VGND sky130_ef_sc_hd__decap_12
X_2368_ _1254_ _1185_ _1198_ VGND VGND VPWR VPWR _1255_ sky130_fd_sc_hd__a21oi_2
X_2299_ _1175_ VGND VGND VPWR VPWR _1187_ sky130_fd_sc_hd__clkbuf_4
X_4107_ regis.header_byte\[3\] _0684_ _1008_ _0988_ VGND VGND VPWR VPWR _1009_ sky130_fd_sc_hd__o2bb2a_1
X_4038_ _0723_ VGND VGND VPWR VPWR _0960_ sky130_fd_sc_hd__clkbuf_4
XFILLER_0_78_121 VPWR VGND VPWR VGND sky130_ef_sc_hd__decap_12
XPHY_105 VGND VGND VPWR VPWR sky130_fd_sc_hd__decap_3
XPHY_116 VGND VGND VPWR VPWR sky130_fd_sc_hd__decap_3
XPHY_149 VGND VGND VPWR VPWR sky130_fd_sc_hd__decap_3
XFILLER_0_19_232 VGND VGND VPWR VPWR sky130_fd_sc_hd__decap_4
XPHY_127 VGND VGND VPWR VPWR sky130_fd_sc_hd__decap_3
XPHY_138 VGND VGND VPWR VPWR sky130_fd_sc_hd__decap_3
XFILLER_0_34_202 VGND VGND VPWR VPWR sky130_fd_sc_hd__fill_2
XFILLER_0_62_533 VGND VGND VPWR VPWR sky130_fd_sc_hd__decap_4
XFILLER_0_6_192 VGND VGND VPWR VPWR sky130_fd_sc_hd__decap_4
XFILLER_0_69_110 VGND VGND VPWR VPWR sky130_fd_sc_hd__fill_2
XPHY_7 VGND VGND VPWR VPWR sky130_fd_sc_hd__decap_3
XFILLER_0_43_39 VPWR VGND VPWR VGND sky130_ef_sc_hd__decap_12
XFILLER_0_84_168 VGND VGND VPWR VPWR sky130_fd_sc_hd__decap_6
XFILLER_0_53_511 VGND VGND VPWR VPWR sky130_fd_sc_hd__fill_1
XFILLER_0_65_393 VPWR VGND VPWR VGND sky130_ef_sc_hd__decap_12
XFILLER_0_80_363 VGND VGND VPWR VPWR sky130_fd_sc_hd__fill_1
XFILLER_0_7_39 VPWR VGND VPWR VGND sky130_ef_sc_hd__decap_12
X_3340_ fifo3.mem\[4\]\[7\] fifo3.mem\[5\]\[7\] fifo3.mem\[6\]\[7\] fifo3.mem\[7\]\[7\]
+ _1864_ _1893_ VGND VGND VPWR VPWR _1965_ sky130_fd_sc_hd__mux4_2
XFILLER_0_0_357 VGND VGND VPWR VPWR sky130_fd_sc_hd__decap_6
XTAP_603 VGND VPWR sky130_fd_sc_hd__tapvpwrvgnd_1
XTAP_614 VGND VPWR sky130_fd_sc_hd__tapvpwrvgnd_1
XTAP_625 VGND VPWR sky130_fd_sc_hd__tapvpwrvgnd_1
X_3271_ _1804_ fifo3.mem\[8\]\[4\] _1841_ VGND VGND VPWR VPWR _1899_ sky130_fd_sc_hd__o21ba_1
XTAP_636 VGND VPWR sky130_fd_sc_hd__tapvpwrvgnd_1
XTAP_647 VGND VPWR sky130_fd_sc_hd__tapvpwrvgnd_1
XTAP_658 VGND VPWR sky130_fd_sc_hd__tapvpwrvgnd_1
XFILLER_0_84_24 VGND VGND VPWR VPWR sky130_fd_sc_hd__decap_4
XTAP_669 VGND VPWR sky130_fd_sc_hd__tapvpwrvgnd_1
X_2222_ _1119_ _1122_ _1136_ VGND VGND VPWR VPWR _1138_ sky130_fd_sc_hd__and3_1
XFILLER_0_84_68 VGND VGND VPWR VPWR sky130_fd_sc_hd__decap_4
X_2153_ _1098_ _1101_ _1103_ net84 VGND VGND VPWR VPWR _0195_ sky130_fd_sc_hd__a22o_1
XFILLER_0_17_95 VPWR VGND VPWR VGND sky130_ef_sc_hd__decap_12
XFILLER_0_88_463 VPWR VGND VPWR VGND sky130_ef_sc_hd__decap_12
XFILLER_0_16_213 VGND VGND VPWR VPWR sky130_fd_sc_hd__fill_1
X_2986_ _1569_ fifo2.mem\[10\]\[5\] _1562_ VGND VGND VPWR VPWR _1689_ sky130_fd_sc_hd__o21ai_1
XFILLER_0_44_511 VPWR VGND VPWR VGND sky130_ef_sc_hd__decap_12
XFILLER_0_44_533 VGND VGND VPWR VPWR sky130_fd_sc_hd__fill_2
X_4725_ clknet_leaf_50_clock _0531_ VGND VGND VPWR VPWR fifo3.rd_pointer\[4\] sky130_fd_sc_hd__dfxtp_1
X_4656_ clknet_leaf_55_clock _0462_ VGND VGND VPWR VPWR fifo3.mem\[14\]\[6\] sky130_fd_sc_hd__dfxtp_1
X_3607_ _0641_ _0642_ _0643_ _0644_ VGND VGND VPWR VPWR _0645_ sky130_fd_sc_hd__o211a_2
X_4587_ clknet_leaf_10_clock _0393_ VGND VGND VPWR VPWR fifo1.mem\[11\]\[7\] sky130_fd_sc_hd__dfxtp_1
X_3538_ _1772_ _1420_ _1774_ _1775_ fifo3.mem\[11\]\[6\] VGND VGND VPWR VPWR _2100_
+ sky130_fd_sc_hd__o311ai_1
X_3469_ _1155_ _1160_ _1161_ VGND VGND VPWR VPWR _0547_ sky130_fd_sc_hd__a21oi_1
XFILLER_0_79_485 VPWR VGND VPWR VGND sky130_ef_sc_hd__decap_12
XFILLER_0_66_168 VGND VGND VPWR VPWR sky130_fd_sc_hd__fill_1
XFILLER_0_62_363 VGND VGND VPWR VPWR sky130_fd_sc_hd__fill_1
Xclkbuf_leaf_6_clock clknet_3_3__leaf_clock VGND VGND VPWR VPWR clknet_leaf_6_clock
+ sky130_fd_sc_hd__clkbuf_16
XFILLER_0_89_249 VPWR VGND VPWR VGND sky130_ef_sc_hd__decap_12
XFILLER_0_85_444 VGND VGND VPWR VPWR sky130_fd_sc_hd__decap_4
XFILLER_0_70_26 VGND VGND VPWR VPWR sky130_fd_sc_hd__fill_2
XFILLER_0_57_146 VGND VGND VPWR VPWR sky130_fd_sc_hd__decap_6
XFILLER_0_70_37 VGND VGND VPWR VPWR sky130_fd_sc_hd__fill_2
X_2840_ _1544_ _1545_ VGND VGND VPWR VPWR _1546_ sky130_fd_sc_hd__nand2_1
XFILLER_0_5_438 VGND VGND VPWR VPWR sky130_fd_sc_hd__decap_8
XFILLER_0_5_405 VPWR VGND VPWR VGND sky130_ef_sc_hd__decap_12
XFILLER_0_26_533 VGND VGND VPWR VPWR sky130_fd_sc_hd__decap_8
X_2771_ _0745_ _1494_ _1495_ net117 VGND VGND VPWR VPWR _0421_ sky130_fd_sc_hd__a22o_1
XFILLER_0_5_449 VGND VGND VPWR VPWR sky130_fd_sc_hd__decap_4
XFILLER_0_41_525 VPWR VGND VPWR VGND sky130_ef_sc_hd__decap_12
X_4510_ clknet_leaf_33_clock _0316_ VGND VGND VPWR VPWR fifo2.mem\[9\]\[2\] sky130_fd_sc_hd__dfxtp_1
X_4441_ clknet_leaf_13_clock _0247_ VGND VGND VPWR VPWR fifo1.mem\[3\]\[8\] sky130_fd_sc_hd__dfxtp_1
XFILLER_0_80_193 VGND VGND VPWR VPWR sky130_fd_sc_hd__decap_3
XFILLER_0_79_68 VGND VGND VPWR VPWR sky130_fd_sc_hd__decap_3
XFILLER_0_79_57 VGND VGND VPWR VPWR sky130_fd_sc_hd__fill_2
Xhold106 fifo2.mem\[3\]\[6\] VGND VGND VPWR VPWR net154 sky130_fd_sc_hd__dlygate4sd3_1
Xhold117 fifo2.mem\[14\]\[7\] VGND VGND VPWR VPWR net165 sky130_fd_sc_hd__dlygate4sd3_1
XFILLER_0_0_110 VGND VGND VPWR VPWR sky130_fd_sc_hd__fill_2
Xhold128 fifo2.mem\[12\]\[0\] VGND VGND VPWR VPWR net176 sky130_fd_sc_hd__dlygate4sd3_1
Xhold139 fifo2.mem\[6\]\[8\] VGND VGND VPWR VPWR net187 sky130_fd_sc_hd__dlygate4sd3_1
XTAP_400 VGND VPWR sky130_fd_sc_hd__tapvpwrvgnd_1
X_4372_ clknet_leaf_1_clock _0186_ VGND VGND VPWR VPWR fifo1.mem\[9\]\[1\] sky130_fd_sc_hd__dfxtp_1
X_3323_ fifo3.mem\[13\]\[6\] _1828_ VGND VGND VPWR VPWR _1949_ sky130_fd_sc_hd__and2b_1
XTAP_411 VGND VPWR sky130_fd_sc_hd__tapvpwrvgnd_1
XTAP_422 VGND VPWR sky130_fd_sc_hd__tapvpwrvgnd_1
XTAP_433 VGND VPWR sky130_fd_sc_hd__tapvpwrvgnd_1
X_3254_ _1879_ _1880_ _1881_ _1882_ VGND VGND VPWR VPWR _1883_ sky130_fd_sc_hd__o22a_1
XTAP_444 VGND VPWR sky130_fd_sc_hd__tapvpwrvgnd_1
XTAP_455 VGND VPWR sky130_fd_sc_hd__tapvpwrvgnd_1
XTAP_466 VGND VPWR sky130_fd_sc_hd__tapvpwrvgnd_1
XFILLER_0_28_72 VGND VGND VPWR VPWR sky130_fd_sc_hd__fill_1
XTAP_477 VGND VPWR sky130_fd_sc_hd__tapvpwrvgnd_1
XTAP_488 VGND VPWR sky130_fd_sc_hd__tapvpwrvgnd_1
XTAP_499 VGND VPWR sky130_fd_sc_hd__tapvpwrvgnd_1
X_2205_ _0759_ _1121_ _1125_ _1128_ VGND VGND VPWR VPWR _0222_ sky130_fd_sc_hd__a31o_1
X_3185_ fifo3.mem\[12\]\[0\] fifo3.mem\[13\]\[0\] fifo3.mem\[14\]\[0\] fifo3.mem\[15\]\[0\]
+ _1805_ _1807_ VGND VGND VPWR VPWR _1817_ sky130_fd_sc_hd__mux4_1
X_2136_ _0757_ _1096_ VGND VGND VPWR VPWR _1097_ sky130_fd_sc_hd__nor2_4
XFILLER_0_76_477 VGND VGND VPWR VPWR sky130_fd_sc_hd__decap_4
XFILLER_0_8_210 VGND VGND VPWR VPWR sky130_fd_sc_hd__fill_1
XFILLER_0_91_436 VPWR VGND VPWR VGND sky130_ef_sc_hd__decap_12
XFILLER_0_29_393 VGND VGND VPWR VPWR sky130_fd_sc_hd__fill_2
X_2969_ _1667_ _1671_ _1542_ VGND VGND VPWR VPWR _1672_ sky130_fd_sc_hd__o21ai_2
X_4708_ clknet_leaf_61_clock _0514_ VGND VGND VPWR VPWR net31 sky130_fd_sc_hd__dfxtp_1
XFILLER_0_32_525 VGND VGND VPWR VPWR sky130_fd_sc_hd__decap_6
X_4639_ clknet_leaf_30_clock _0445_ VGND VGND VPWR VPWR fifo2.count\[5\] sky130_fd_sc_hd__dfxtp_1
XFILLER_0_79_293 VGND VGND VPWR VPWR sky130_fd_sc_hd__fill_2
XFILLER_0_82_403 VGND VGND VPWR VPWR sky130_fd_sc_hd__decap_4
XFILLER_0_82_414 VGND VGND VPWR VPWR sky130_fd_sc_hd__decap_6
XFILLER_0_82_458 VPWR VGND VPWR VGND sky130_ef_sc_hd__decap_12
XFILLER_0_40_29 VPWR VGND VPWR VGND sky130_ef_sc_hd__decap_12
XFILLER_0_54_149 VGND VGND VPWR VPWR sky130_fd_sc_hd__decap_3
XFILLER_0_2_419 VGND VGND VPWR VPWR sky130_fd_sc_hd__fill_1
XFILLER_0_4_29 VPWR VGND VPWR VGND sky130_ef_sc_hd__decap_12
XFILLER_0_65_15 VGND VGND VPWR VPWR sky130_fd_sc_hd__decap_3
XFILLER_0_65_26 VPWR VGND VPWR VGND sky130_ef_sc_hd__decap_12
X_3941_ syn.count2\[1\] syn.count2\[5\] syn.count2\[4\] syn.count2\[0\] VGND VGND
+ VPWR VPWR _0897_ sky130_fd_sc_hd__and4bb_1
XFILLER_0_58_477 VGND VGND VPWR VPWR sky130_fd_sc_hd__fill_2
XFILLER_0_73_425 VGND VGND VPWR VPWR sky130_fd_sc_hd__decap_6
XFILLER_0_14_85 VGND VGND VPWR VPWR sky130_fd_sc_hd__fill_2
X_3872_ _0766_ _0825_ _0830_ _0849_ VGND VGND VPWR VPWR _0069_ sky130_fd_sc_hd__a31o_1
XFILLER_0_73_447 VGND VGND VPWR VPWR sky130_fd_sc_hd__fill_1
X_2823_ _1282_ _0983_ VGND VGND VPWR VPWR _1533_ sky130_fd_sc_hd__and2_1
X_2754_ _1105_ _1491_ _1492_ net219 VGND VGND VPWR VPWR _0407_ sky130_fd_sc_hd__a22o_1
XFILLER_0_81_480 VPWR VGND VPWR VGND sky130_ef_sc_hd__decap_12
XFILLER_0_41_333 VGND VGND VPWR VPWR sky130_fd_sc_hd__decap_3
X_2685_ _1467_ _1438_ _0962_ fifo2.mem\[2\]\[2\] _0967_ VGND VGND VPWR VPWR _1470_
+ sky130_fd_sc_hd__o311a_1
XFILLER_0_1_441 VGND VGND VPWR VPWR sky130_fd_sc_hd__decap_6
X_4424_ clknet_leaf_5_clock _0238_ VGND VGND VPWR VPWR fifo1.mem\[6\]\[8\] sky130_fd_sc_hd__dfxtp_1
X_4355_ clknet_leaf_45_clock _0169_ VGND VGND VPWR VPWR regis.packet_parity\[2\] sky130_fd_sc_hd__dfxtp_1
XFILLER_0_1_485 VPWR VGND VPWR VGND sky130_ef_sc_hd__decap_12
X_3306_ fifo3.mem\[9\]\[5\] _1838_ VGND VGND VPWR VPWR _1933_ sky130_fd_sc_hd__nor2_1
XTAP_241 VGND VPWR sky130_fd_sc_hd__tapvpwrvgnd_1
XTAP_230 VGND VPWR sky130_fd_sc_hd__tapvpwrvgnd_1
XTAP_274 VGND VPWR sky130_fd_sc_hd__tapvpwrvgnd_1
XTAP_263 VGND VPWR sky130_fd_sc_hd__tapvpwrvgnd_1
XTAP_252 VGND VPWR sky130_fd_sc_hd__tapvpwrvgnd_1
X_4286_ clknet_leaf_43_clock _0100_ VGND VGND VPWR VPWR regis.fifo_full_state\[3\]
+ sky130_fd_sc_hd__dfxtp_1
XTAP_296 VGND VPWR sky130_fd_sc_hd__tapvpwrvgnd_1
XTAP_285 VGND VPWR sky130_fd_sc_hd__tapvpwrvgnd_1
X_3237_ _1863_ _1864_ _1865_ VGND VGND VPWR VPWR _1866_ sky130_fd_sc_hd__a21oi_1
X_3168_ net286 _1801_ _1803_ _0763_ VGND VGND VPWR VPWR _0510_ sky130_fd_sc_hd__a22o_1
X_2119_ net39 _1069_ _0996_ _1089_ VGND VGND VPWR VPWR _0175_ sky130_fd_sc_hd__o211a_1
X_3099_ _1770_ VGND VGND VPWR VPWR _1771_ sky130_fd_sc_hd__buf_2
XFILLER_0_49_488 VGND VGND VPWR VPWR sky130_fd_sc_hd__decap_3
XFILLER_0_64_403 VGND VGND VPWR VPWR sky130_fd_sc_hd__fill_2
XFILLER_0_87_517 VPWR VGND VPWR VGND sky130_ef_sc_hd__decap_12
Xclkbuf_leaf_24_clock clknet_3_6__leaf_clock VGND VGND VPWR VPWR clknet_leaf_24_clock
+ sky130_fd_sc_hd__clkbuf_16
XFILLER_0_67_241 VGND VGND VPWR VPWR sky130_fd_sc_hd__decap_8
XFILLER_0_55_414 VGND VGND VPWR VPWR sky130_fd_sc_hd__decap_6
XFILLER_0_27_149 VGND VGND VPWR VPWR sky130_fd_sc_hd__fill_2
Xclkbuf_leaf_39_clock clknet_3_5__leaf_clock VGND VGND VPWR VPWR clknet_leaf_39_clock
+ sky130_fd_sc_hd__clkbuf_16
XFILLER_0_70_417 VGND VGND VPWR VPWR sky130_fd_sc_hd__decap_3
XFILLER_0_82_299 VGND VGND VPWR VPWR sky130_fd_sc_hd__decap_8
X_2470_ _1219_ _1226_ VGND VGND VPWR VPWR _1353_ sky130_fd_sc_hd__nand2_1
XFILLER_0_11_517 VPWR VGND VPWR VGND sky130_ef_sc_hd__decap_12
XFILLER_0_76_36 VPWR VGND VPWR VGND sky130_ef_sc_hd__decap_12
X_4140_ net4 _1027_ _0875_ _1033_ VGND VGND VPWR VPWR _0153_ sky130_fd_sc_hd__o211a_1
X_4071_ _0976_ _0867_ net328 net47 _0980_ VGND VGND VPWR VPWR _0137_ sky130_fd_sc_hd__a32o_1
X_3022_ _1543_ _1546_ _1625_ VGND VGND VPWR VPWR _1723_ sky130_fd_sc_hd__a21oi_1
XFILLER_0_25_62 VPWR VGND VPWR VGND sky130_ef_sc_hd__decap_12
XFILLER_0_58_230 VGND VGND VPWR VPWR sky130_fd_sc_hd__decap_3
X_3924_ syn.count1\[0\] syn.count1\[1\] syn.count1\[2\] syn.count1\[3\] VGND VGND
+ VPWR VPWR _0885_ sky130_fd_sc_hd__a31o_1
XFILLER_0_73_200 VGND VGND VPWR VPWR sky130_fd_sc_hd__decap_8
XFILLER_0_73_222 VGND VGND VPWR VPWR sky130_fd_sc_hd__fill_2
XFILLER_0_18_127 VGND VGND VPWR VPWR sky130_fd_sc_hd__fill_1
XFILLER_0_6_533 VGND VGND VPWR VPWR sky130_fd_sc_hd__decap_4
X_3855_ _0832_ VGND VGND VPWR VPWR _0839_ sky130_fd_sc_hd__clkbuf_4
X_2806_ fifo1.mem\[0\]\[0\] fifo1.mem\[1\]\[0\] fifo1.mem\[2\]\[0\] fifo1.mem\[3\]\[0\]
+ _1317_ _1339_ VGND VGND VPWR VPWR _1520_ sky130_fd_sc_hd__mux4_1
X_3786_ _0785_ _0786_ fifo3.mem\[7\]\[1\] VGND VGND VPWR VPWR _0788_ sky130_fd_sc_hd__and3_1
X_2737_ _1487_ VGND VGND VPWR VPWR _1488_ sky130_fd_sc_hd__clkbuf_4
XFILLER_0_74_3 VGND VGND VPWR VPWR sky130_fd_sc_hd__decap_6
XFILLER_0_14_399 VGND VGND VPWR VPWR sky130_fd_sc_hd__decap_8
X_2668_ fifo1.wr_pointer\[0\] _0751_ _0753_ _1150_ VGND VGND VPWR VPWR _1464_ sky130_fd_sc_hd__and4_1
XFILLER_0_41_196 VGND VGND VPWR VPWR sky130_fd_sc_hd__fill_1
X_4407_ clknet_leaf_8_clock _0221_ VGND VGND VPWR VPWR fifo1.mem\[7\]\[0\] sky130_fd_sc_hd__dfxtp_1
X_2599_ _1435_ _0867_ fifo2.mem\[10\]\[3\] _0864_ _1426_ VGND VGND VPWR VPWR _0308_
+ sky130_fd_sc_hd__a32o_1
X_4338_ clknet_leaf_45_clock _0152_ VGND VGND VPWR VPWR regis.header_byte\[2\] sky130_fd_sc_hd__dfxtp_1
X_4269_ clknet_leaf_26_clock _0083_ VGND VGND VPWR VPWR syn.count1\[0\] sky130_fd_sc_hd__dfxtp_2
XFILLER_0_66_80 VGND VGND VPWR VPWR sky130_fd_sc_hd__decap_4
XFILLER_0_69_539 VGND VGND VPWR VPWR sky130_fd_sc_hd__fill_2
XFILLER_0_64_211 VGND VGND VPWR VPWR sky130_fd_sc_hd__decap_4
XFILLER_0_37_447 VGND VGND VPWR VPWR sky130_fd_sc_hd__fill_1
XFILLER_0_64_244 VGND VGND VPWR VPWR sky130_fd_sc_hd__decap_4
XFILLER_0_37_469 VPWR VGND VPWR VGND sky130_ef_sc_hd__decap_12
XFILLER_0_52_417 VGND VGND VPWR VPWR sky130_fd_sc_hd__decap_3
XFILLER_0_64_277 VGND VGND VPWR VPWR sky130_fd_sc_hd__fill_2
XFILLER_0_52_439 VGND VGND VPWR VPWR sky130_fd_sc_hd__fill_1
XFILLER_0_43_417 VGND VGND VPWR VPWR sky130_fd_sc_hd__decap_4
XFILLER_0_3_503 VGND VGND VPWR VPWR sky130_fd_sc_hd__fill_1
X_3640_ _0673_ fsm1.present_state\[4\] _0674_ _0669_ VGND VGND VPWR VPWR _0675_ sky130_fd_sc_hd__o2bb2ai_1
XFILLER_0_23_141 VGND VGND VPWR VPWR sky130_fd_sc_hd__fill_1
X_3571_ _0606_ _0607_ _0608_ _0609_ VGND VGND VPWR VPWR _0610_ sky130_fd_sc_hd__o22a_4
XFILLER_0_11_303 VGND VGND VPWR VPWR sky130_fd_sc_hd__fill_1
X_2522_ net42 _1402_ net12 VGND VGND VPWR VPWR _1403_ sky130_fd_sc_hd__and3_1
X_2453_ _1296_ fifo1.mem\[8\]\[6\] _1178_ VGND VGND VPWR VPWR _1337_ sky130_fd_sc_hd__o21ba_1
X_2384_ _1267_ _1269_ _0002_ VGND VGND VPWR VPWR _1270_ sky130_fd_sc_hd__a21o_1
X_4123_ _1019_ _1021_ _1005_ VGND VGND VPWR VPWR _0148_ sky130_fd_sc_hd__a21boi_1
X_4054_ _0957_ _0961_ _0962_ fifo2.mem\[1\]\[8\] _0967_ VGND VGND VPWR VPWR _0970_
+ sky130_fd_sc_hd__o311a_1
Xinput2 data_in[1] VGND VGND VPWR VPWR net2 sky130_fd_sc_hd__clkbuf_2
X_3005_ _1582_ fifo2.mem\[1\]\[6\] _1706_ VGND VGND VPWR VPWR _1707_ sky130_fd_sc_hd__o21ai_1
XFILLER_0_19_447 VGND VGND VPWR VPWR sky130_fd_sc_hd__fill_1
X_3907_ _0800_ VGND VGND VPWR VPWR _0874_ sky130_fd_sc_hd__buf_4
XFILLER_0_46_244 VGND VGND VPWR VPWR sky130_fd_sc_hd__decap_8
X_3838_ fifo3.wr_pointer\[1\] VGND VGND VPWR VPWR _0823_ sky130_fd_sc_hd__clkbuf_4
XFILLER_0_61_225 VPWR VGND VPWR VGND sky130_ef_sc_hd__decap_12
X_3769_ _0771_ VGND VGND VPWR VPWR _0772_ sky130_fd_sc_hd__clkbuf_4
XFILLER_0_69_314 VGND VGND VPWR VPWR sky130_fd_sc_hd__fill_2
XTAP_1012 VGND VPWR sky130_fd_sc_hd__tapvpwrvgnd_1
XTAP_1001 VGND VPWR sky130_fd_sc_hd__tapvpwrvgnd_1
XTAP_1056 VGND VPWR sky130_fd_sc_hd__tapvpwrvgnd_1
XTAP_1045 VGND VPWR sky130_fd_sc_hd__tapvpwrvgnd_1
XTAP_1034 VGND VPWR sky130_fd_sc_hd__tapvpwrvgnd_1
XTAP_1023 VGND VPWR sky130_fd_sc_hd__tapvpwrvgnd_1
XFILLER_0_84_328 VPWR VGND VPWR VGND sky130_ef_sc_hd__decap_12
XTAP_1067 VGND VPWR sky130_fd_sc_hd__tapvpwrvgnd_1
XFILLER_0_80_501 VPWR VGND VPWR VGND sky130_ef_sc_hd__decap_12
XFILLER_0_52_247 VGND VGND VPWR VPWR sky130_fd_sc_hd__decap_4
XTAP_807 VGND VPWR sky130_fd_sc_hd__tapvpwrvgnd_1
XFILLER_0_20_188 VGND VGND VPWR VPWR sky130_fd_sc_hd__decap_8
XTAP_818 VGND VPWR sky130_fd_sc_hd__tapvpwrvgnd_1
XTAP_829 VGND VPWR sky130_fd_sc_hd__tapvpwrvgnd_1
XFILLER_0_73_37 VGND VGND VPWR VPWR sky130_fd_sc_hd__decap_3
XFILLER_0_73_15 VGND VGND VPWR VPWR sky130_fd_sc_hd__fill_2
XFILLER_0_56_531 VGND VGND VPWR VPWR sky130_fd_sc_hd__fill_1
XFILLER_0_90_309 VPWR VGND VPWR VGND sky130_ef_sc_hd__decap_12
XFILLER_0_83_361 VPWR VGND VPWR VGND sky130_ef_sc_hd__decap_12
X_4741_ clknet_leaf_20_clock _0547_ VGND VGND VPWR VPWR _0000_ sky130_fd_sc_hd__dfxtp_1
XFILLER_0_16_417 VGND VGND VPWR VPWR sky130_fd_sc_hd__decap_3
X_4672_ clknet_leaf_59_clock _0478_ VGND VGND VPWR VPWR fifo3.mem\[9\]\[4\] sky130_fd_sc_hd__dfxtp_1
XFILLER_0_22_74 VGND VGND VPWR VPWR sky130_fd_sc_hd__decap_3
XFILLER_0_22_85 VGND VGND VPWR VPWR sky130_fd_sc_hd__fill_1
XFILLER_0_43_225 VGND VGND VPWR VPWR sky130_fd_sc_hd__decap_6
X_3623_ _0658_ _0659_ _0660_ VGND VGND VPWR VPWR _0661_ sky130_fd_sc_hd__and3b_1
XFILLER_0_11_111 VGND VGND VPWR VPWR sky130_fd_sc_hd__fill_1
X_3554_ _0765_ _2105_ _2103_ _2104_ net167 VGND VGND VPWR VPWR _0594_ sky130_fd_sc_hd__a32o_1
X_2505_ _1374_ _1372_ VGND VGND VPWR VPWR _1388_ sky130_fd_sc_hd__and2_1
XFILLER_0_11_166 VGND VGND VPWR VPWR sky130_fd_sc_hd__fill_2
X_3485_ _2072_ _0783_ net313 _2076_ VGND VGND VPWR VPWR _0554_ sky130_fd_sc_hd__a31o_1
X_2436_ _1176_ fifo1.mem\[10\]\[5\] _1233_ VGND VGND VPWR VPWR _1321_ sky130_fd_sc_hd__o21a_1
XFILLER_0_37_3 VPWR VGND VPWR VGND sky130_ef_sc_hd__decap_12
X_2367_ _1250_ _1251_ _1252_ _1253_ VGND VGND VPWR VPWR _1254_ sky130_fd_sc_hd__o22ai_1
X_2298_ _1184_ _1185_ VGND VGND VPWR VPWR _1186_ sky130_fd_sc_hd__nand2_1
X_4106_ fifo1.lfd_state fifo1.data_in\[3\] VGND VGND VPWR VPWR _1008_ sky130_fd_sc_hd__or2b_1
X_4037_ _0732_ _0741_ _0956_ _0959_ net125 VGND VGND VPWR VPWR _0124_ sky130_fd_sc_hd__a32o_1
XFILLER_0_78_133 VGND VGND VPWR VPWR sky130_fd_sc_hd__decap_6
XPHY_106 VGND VGND VPWR VPWR sky130_fd_sc_hd__decap_3
XFILLER_0_63_70 VGND VGND VPWR VPWR sky130_fd_sc_hd__decap_3
XPHY_117 VGND VGND VPWR VPWR sky130_fd_sc_hd__decap_3
XFILLER_0_59_391 VGND VGND VPWR VPWR sky130_fd_sc_hd__fill_1
XPHY_128 VGND VGND VPWR VPWR sky130_fd_sc_hd__decap_3
XPHY_139 VGND VGND VPWR VPWR sky130_fd_sc_hd__decap_3
XFILLER_0_34_214 VGND VGND VPWR VPWR sky130_fd_sc_hd__decap_4
XFILLER_0_15_483 VGND VGND VPWR VPWR sky130_fd_sc_hd__decap_4
XPHY_8 VGND VGND VPWR VPWR sky130_fd_sc_hd__decap_3
XFILLER_0_69_166 VGND VGND VPWR VPWR sky130_fd_sc_hd__fill_2
XFILLER_0_38_531 VGND VGND VPWR VPWR sky130_fd_sc_hd__fill_1
XFILLER_0_72_309 VGND VGND VPWR VPWR sky130_fd_sc_hd__fill_2
XFILLER_0_65_372 VGND VGND VPWR VPWR sky130_fd_sc_hd__decap_4
XFILLER_0_65_383 VGND VGND VPWR VPWR sky130_fd_sc_hd__decap_8
XFILLER_0_80_331 VPWR VGND VPWR VGND sky130_ef_sc_hd__decap_12
XFILLER_0_4_119 VGND VGND VPWR VPWR sky130_fd_sc_hd__decap_4
XFILLER_0_40_239 VGND VGND VPWR VPWR sky130_fd_sc_hd__fill_1
X_3270_ _1893_ _1894_ _1895_ _1897_ VGND VGND VPWR VPWR _1898_ sky130_fd_sc_hd__o31a_1
XTAP_604 VGND VPWR sky130_fd_sc_hd__tapvpwrvgnd_1
XTAP_615 VGND VPWR sky130_fd_sc_hd__tapvpwrvgnd_1
XTAP_626 VGND VPWR sky130_fd_sc_hd__tapvpwrvgnd_1
XTAP_637 VGND VPWR sky130_fd_sc_hd__tapvpwrvgnd_1
XTAP_648 VGND VPWR sky130_fd_sc_hd__tapvpwrvgnd_1
XTAP_659 VGND VPWR sky130_fd_sc_hd__tapvpwrvgnd_1
X_2221_ _1122_ _1136_ _0757_ VGND VGND VPWR VPWR _1137_ sky130_fd_sc_hd__a21oi_4
X_2152_ _0747_ _1101_ _1103_ net238 VGND VGND VPWR VPWR _0194_ sky130_fd_sc_hd__a22o_1
XFILLER_0_88_475 VGND VGND VPWR VPWR sky130_fd_sc_hd__fill_1
XFILLER_0_75_147 VGND VGND VPWR VPWR sky130_fd_sc_hd__decap_8
XFILLER_0_8_414 VGND VGND VPWR VPWR sky130_fd_sc_hd__decap_6
XFILLER_0_90_139 VGND VGND VPWR VPWR sky130_fd_sc_hd__fill_1
X_4724_ clknet_leaf_50_clock _0530_ VGND VGND VPWR VPWR fifo3.rd_pointer\[3\] sky130_fd_sc_hd__dfxtp_1
X_2985_ fifo2.mem\[11\]\[5\] VGND VGND VPWR VPWR _1688_ sky130_fd_sc_hd__inv_2
XFILLER_0_44_523 VGND VGND VPWR VPWR sky130_fd_sc_hd__decap_8
XFILLER_0_71_331 VGND VGND VPWR VPWR sky130_fd_sc_hd__decap_4
XFILLER_0_16_269 VPWR VGND VPWR VGND sky130_ef_sc_hd__decap_12
X_4655_ clknet_leaf_48_clock _0461_ VGND VGND VPWR VPWR fifo3.mem\[14\]\[5\] sky130_fd_sc_hd__dfxtp_1
X_3606_ fifo3.rd_pointer\[1\] fifo3.wr_pointer\[1\] VGND VGND VPWR VPWR _0644_ sky130_fd_sc_hd__or2b_1
X_4586_ clknet_leaf_8_clock _0392_ VGND VGND VPWR VPWR fifo1.mem\[11\]\[6\] sky130_fd_sc_hd__dfxtp_1
X_3537_ _0934_ _2094_ _2099_ VGND VGND VPWR VPWR _0583_ sky130_fd_sc_hd__a21bo_1
X_3468_ _2019_ _2060_ _0921_ _2067_ VGND VGND VPWR VPWR _0546_ sky130_fd_sc_hd__a211oi_1
XFILLER_0_58_70 VGND VGND VPWR VPWR sky130_fd_sc_hd__decap_4
X_2419_ _1296_ fifo1.mem\[0\]\[5\] _1233_ VGND VGND VPWR VPWR _1304_ sky130_fd_sc_hd__o21bai_1
X_3399_ _2006_ VGND VGND VPWR VPWR _0538_ sky130_fd_sc_hd__clkbuf_1
XFILLER_0_74_80 VGND VGND VPWR VPWR sky130_fd_sc_hd__decap_4
XFILLER_0_79_497 VGND VGND VPWR VPWR sky130_fd_sc_hd__decap_6
XFILLER_0_66_114 VGND VGND VPWR VPWR sky130_fd_sc_hd__fill_1
XFILLER_0_66_125 VGND VGND VPWR VPWR sky130_fd_sc_hd__decap_8
XFILLER_0_81_106 VGND VGND VPWR VPWR sky130_fd_sc_hd__decap_6
XFILLER_0_38_29 VGND VGND VPWR VPWR sky130_fd_sc_hd__decap_8
XFILLER_0_89_206 VPWR VGND VPWR VGND sky130_ef_sc_hd__decap_12
XFILLER_0_57_169 VGND VGND VPWR VPWR sky130_fd_sc_hd__decap_4
XFILLER_0_72_139 VGND VGND VPWR VPWR sky130_fd_sc_hd__fill_1
XFILLER_0_5_417 VGND VGND VPWR VPWR sky130_fd_sc_hd__decap_4
X_2770_ _1109_ _1494_ _1495_ net190 VGND VGND VPWR VPWR _0420_ sky130_fd_sc_hd__a22o_1
XFILLER_0_13_206 VPWR VGND VPWR VGND sky130_ef_sc_hd__decap_12
XFILLER_0_53_375 VGND VGND VPWR VPWR sky130_fd_sc_hd__fill_2
X_4440_ clknet_leaf_13_clock _0246_ VGND VGND VPWR VPWR fifo1.mem\[3\]\[7\] sky130_fd_sc_hd__dfxtp_1
XFILLER_0_41_537 VGND VGND VPWR VPWR sky130_fd_sc_hd__decap_4
Xhold107 fifo1.mem\[10\]\[6\] VGND VGND VPWR VPWR net155 sky130_fd_sc_hd__dlygate4sd3_1
Xhold118 fifo1.mem\[13\]\[7\] VGND VGND VPWR VPWR net166 sky130_fd_sc_hd__dlygate4sd3_1
Xhold129 fifo1.mem\[2\]\[8\] VGND VGND VPWR VPWR net177 sky130_fd_sc_hd__dlygate4sd3_1
XFILLER_0_21_261 VGND VGND VPWR VPWR sky130_fd_sc_hd__fill_1
X_4371_ clknet_leaf_8_clock _0185_ VGND VGND VPWR VPWR fifo1.mem\[9\]\[0\] sky130_fd_sc_hd__dfxtp_1
X_3322_ _1832_ fifo3.mem\[12\]\[6\] _1857_ VGND VGND VPWR VPWR _1948_ sky130_fd_sc_hd__o21bai_1
XTAP_401 VGND VPWR sky130_fd_sc_hd__tapvpwrvgnd_1
XTAP_412 VGND VPWR sky130_fd_sc_hd__tapvpwrvgnd_1
XTAP_423 VGND VPWR sky130_fd_sc_hd__tapvpwrvgnd_1
X_3253_ fifo3.mem\[9\]\[3\] _1804_ VGND VGND VPWR VPWR _1882_ sky130_fd_sc_hd__and2b_1
XTAP_434 VGND VPWR sky130_fd_sc_hd__tapvpwrvgnd_1
XTAP_445 VGND VPWR sky130_fd_sc_hd__tapvpwrvgnd_1
XTAP_456 VGND VPWR sky130_fd_sc_hd__tapvpwrvgnd_1
XTAP_467 VGND VPWR sky130_fd_sc_hd__tapvpwrvgnd_1
X_3184_ _0011_ VGND VGND VPWR VPWR _1816_ sky130_fd_sc_hd__clkinv_4
XTAP_478 VGND VPWR sky130_fd_sc_hd__tapvpwrvgnd_1
XTAP_489 VGND VPWR sky130_fd_sc_hd__tapvpwrvgnd_1
X_2204_ _1126_ _1120_ fifo1.mem\[7\]\[1\] VGND VGND VPWR VPWR _1128_ sky130_fd_sc_hd__and3_1
X_2135_ _1095_ VGND VGND VPWR VPWR _1096_ sky130_fd_sc_hd__clkbuf_4
XFILLER_0_48_103 VGND VGND VPWR VPWR sky130_fd_sc_hd__decap_4
XFILLER_0_36_309 VPWR VGND VPWR VGND sky130_ef_sc_hd__decap_12
X_2968_ _1668_ _1669_ _1670_ VGND VGND VPWR VPWR _1671_ sky130_fd_sc_hd__a21oi_1
X_4707_ clknet_leaf_15_clock _0513_ VGND VGND VPWR VPWR fifo1.mem\[14\]\[8\] sky130_fd_sc_hd__dfxtp_1
XFILLER_0_44_397 VGND VGND VPWR VPWR sky130_fd_sc_hd__fill_2
X_2899_ _1601_ _1603_ _0006_ VGND VGND VPWR VPWR _1604_ sky130_fd_sc_hd__a21o_1
X_4638_ clknet_leaf_30_clock _0444_ VGND VGND VPWR VPWR fifo2.count\[4\] sky130_fd_sc_hd__dfxtp_1
XFILLER_0_8_83 VGND VGND VPWR VPWR sky130_fd_sc_hd__fill_1
X_4569_ clknet_leaf_24_clock _0375_ VGND VGND VPWR VPWR fifo2.mem\[5\]\[7\] sky130_fd_sc_hd__dfxtp_1
XTAP_990 VGND VPWR sky130_fd_sc_hd__tapvpwrvgnd_1
XFILLER_0_39_125 VGND VGND VPWR VPWR sky130_fd_sc_hd__fill_2
XFILLER_0_27_309 VGND VGND VPWR VPWR sky130_fd_sc_hd__fill_1
XFILLER_0_82_437 VGND VGND VPWR VPWR sky130_fd_sc_hd__fill_1
XFILLER_0_50_301 VGND VGND VPWR VPWR sky130_fd_sc_hd__fill_1
XFILLER_0_49_28 VGND VGND VPWR VPWR sky130_fd_sc_hd__decap_6
XFILLER_0_65_38 VPWR VGND VPWR VGND sky130_ef_sc_hd__decap_12
XFILLER_0_58_401 VGND VGND VPWR VPWR sky130_fd_sc_hd__fill_1
X_3940_ syn.count2\[0\] syn.count2\[1\] VGND VGND VPWR VPWR _0896_ sky130_fd_sc_hd__and2b_1
X_3871_ _0832_ _0840_ _0841_ _0844_ fifo3.mem\[1\]\[7\] VGND VGND VPWR VPWR _0849_
+ sky130_fd_sc_hd__o311a_1
XFILLER_0_58_489 VPWR VGND VPWR VGND sky130_ef_sc_hd__decap_12
X_2822_ _1532_ VGND VGND VPWR VPWR _0435_ sky130_fd_sc_hd__clkbuf_1
XFILLER_0_90_9 VPWR VGND VPWR VGND sky130_ef_sc_hd__decap_12
XFILLER_0_5_225 VGND VGND VPWR VPWR sky130_fd_sc_hd__decap_8
XFILLER_0_30_41 VGND VGND VPWR VPWR sky130_fd_sc_hd__decap_6
X_2753_ _1104_ _1491_ _1492_ net231 VGND VGND VPWR VPWR _0406_ sky130_fd_sc_hd__a22o_1
XFILLER_0_81_492 VPWR VGND VPWR VGND sky130_ef_sc_hd__decap_12
XFILLER_0_30_63 VGND VGND VPWR VPWR sky130_fd_sc_hd__fill_2
X_2684_ _0759_ _0960_ _1436_ _1469_ VGND VGND VPWR VPWR _0360_ sky130_fd_sc_hd__a31o_1
XFILLER_0_30_85 VPWR VGND VPWR VGND sky130_ef_sc_hd__decap_12
X_4423_ clknet_leaf_5_clock _0237_ VGND VGND VPWR VPWR fifo1.mem\[6\]\[7\] sky130_fd_sc_hd__dfxtp_1
X_4354_ clknet_leaf_47_clock _0168_ VGND VGND VPWR VPWR regis.packet_parity\[1\] sky130_fd_sc_hd__dfxtp_1
X_3305_ _1849_ fifo3.mem\[8\]\[5\] _1835_ VGND VGND VPWR VPWR _1932_ sky130_fd_sc_hd__o21bai_1
XTAP_242 VGND VPWR sky130_fd_sc_hd__tapvpwrvgnd_1
XFILLER_0_1_497 VGND VGND VPWR VPWR sky130_fd_sc_hd__decap_6
XTAP_220 VGND VPWR sky130_fd_sc_hd__tapvpwrvgnd_1
XTAP_231 VGND VPWR sky130_fd_sc_hd__tapvpwrvgnd_1
XTAP_275 VGND VPWR sky130_fd_sc_hd__tapvpwrvgnd_1
XTAP_264 VGND VPWR sky130_fd_sc_hd__tapvpwrvgnd_1
XTAP_253 VGND VPWR sky130_fd_sc_hd__tapvpwrvgnd_1
X_4285_ clknet_leaf_42_clock _0099_ VGND VGND VPWR VPWR regis.fifo_full_state\[2\]
+ sky130_fd_sc_hd__dfxtp_1
X_3236_ _1846_ fifo3.mem\[4\]\[3\] _1841_ VGND VGND VPWR VPWR _1865_ sky130_fd_sc_hd__o21bai_1
XTAP_297 VGND VPWR sky130_fd_sc_hd__tapvpwrvgnd_1
XTAP_286 VGND VPWR sky130_fd_sc_hd__tapvpwrvgnd_1
X_3167_ net174 _1801_ _1803_ _0762_ VGND VGND VPWR VPWR _0509_ sky130_fd_sc_hd__a22o_1
X_2118_ _1077_ _1086_ _1087_ _1088_ VGND VGND VPWR VPWR _1089_ sky130_fd_sc_hd__or4b_1
X_3098_ _0770_ _0781_ _0803_ _0824_ VGND VGND VPWR VPWR _1770_ sky130_fd_sc_hd__and4b_1
Xclkbuf_leaf_5_clock clknet_3_3__leaf_clock VGND VGND VPWR VPWR clknet_leaf_5_clock
+ sky130_fd_sc_hd__clkbuf_16
XFILLER_0_76_253 VGND VGND VPWR VPWR sky130_fd_sc_hd__decap_8
XFILLER_0_87_529 VPWR VGND VPWR VGND sky130_ef_sc_hd__decap_12
XFILLER_0_55_426 VGND VGND VPWR VPWR sky130_fd_sc_hd__decap_6
XFILLER_0_82_223 VPWR VGND VPWR VGND sky130_ef_sc_hd__decap_12
XFILLER_0_70_407 VGND VGND VPWR VPWR sky130_fd_sc_hd__fill_2
XFILLER_0_23_301 VGND VGND VPWR VPWR sky130_fd_sc_hd__fill_2
XFILLER_0_11_529 VPWR VGND VPWR VGND sky130_ef_sc_hd__decap_12
XFILLER_0_76_15 VGND VGND VPWR VPWR sky130_fd_sc_hd__fill_2
XFILLER_0_76_48 VGND VGND VPWR VPWR sky130_fd_sc_hd__decap_3
X_4070_ _0739_ _0859_ _0972_ VGND VGND VPWR VPWR _0980_ sky130_fd_sc_hd__and3_1
X_3021_ _1552_ _1721_ _1538_ VGND VGND VPWR VPWR _1722_ sky130_fd_sc_hd__a21oi_1
XFILLER_0_25_74 VPWR VGND VPWR VGND sky130_ef_sc_hd__decap_12
X_3923_ _0883_ _0884_ _0882_ VGND VGND VPWR VPWR _0085_ sky130_fd_sc_hd__nor3_1
XFILLER_0_73_245 VGND VGND VPWR VPWR sky130_fd_sc_hd__fill_1
X_3854_ _0837_ VGND VGND VPWR VPWR _0838_ sky130_fd_sc_hd__clkbuf_4
X_2805_ _1518_ _1200_ VGND VGND VPWR VPWR _1519_ sky130_fd_sc_hd__and2_1
XFILLER_0_33_109 VGND VGND VPWR VPWR sky130_fd_sc_hd__decap_3
XFILLER_0_41_51 VGND VGND VPWR VPWR sky130_fd_sc_hd__decap_4
X_3785_ _0747_ _0778_ _0783_ _0787_ VGND VGND VPWR VPWR _0044_ sky130_fd_sc_hd__a31o_1
XFILLER_0_14_334 VGND VGND VPWR VPWR sky130_fd_sc_hd__fill_1
X_2736_ _1119_ _1111_ _1094_ _1112_ VGND VGND VPWR VPWR _1487_ sky130_fd_sc_hd__and4_1
X_2667_ _0768_ _1462_ _1463_ net89 VGND VGND VPWR VPWR _0349_ sky130_fd_sc_hd__a22o_1
X_4406_ clknet_leaf_8_clock _0220_ VGND VGND VPWR VPWR fifo1.mem\[8\]\[8\] sky130_fd_sc_hd__dfxtp_1
XFILLER_0_67_3 VGND VGND VPWR VPWR sky130_fd_sc_hd__fill_1
X_2598_ _1435_ _0867_ fifo2.mem\[10\]\[2\] _0863_ _1426_ VGND VGND VPWR VPWR _0307_
+ sky130_fd_sc_hd__a32o_1
X_4337_ clknet_leaf_39_clock _0151_ VGND VGND VPWR VPWR regis.header_byte\[1\] sky130_fd_sc_hd__dfxtp_1
X_4268_ clknet_leaf_24_clock _0082_ VGND VGND VPWR VPWR fifo1.soft_reset sky130_fd_sc_hd__dfxtp_2
X_3219_ _0008_ VGND VGND VPWR VPWR _1849_ sky130_fd_sc_hd__buf_4
X_4199_ regis.packet_parity\[5\] regis.internal_parity\[5\] VGND VGND VPWR VPWR _1071_
+ sky130_fd_sc_hd__nand2_1
XFILLER_0_77_540 VGND VGND VPWR VPWR sky130_fd_sc_hd__fill_1
XFILLER_0_49_220 VGND VGND VPWR VPWR sky130_fd_sc_hd__decap_4
XFILLER_0_9_383 VGND VGND VPWR VPWR sky130_fd_sc_hd__decap_8
XFILLER_0_17_161 VGND VGND VPWR VPWR sky130_fd_sc_hd__decap_6
XFILLER_0_45_481 VGND VGND VPWR VPWR sky130_fd_sc_hd__fill_1
XFILLER_0_32_153 VGND VGND VPWR VPWR sky130_fd_sc_hd__fill_1
XFILLER_0_20_326 VGND VGND VPWR VPWR sky130_fd_sc_hd__decap_6
Xhold290 fifo2.mem\[5\]\[5\] VGND VGND VPWR VPWR net338 sky130_fd_sc_hd__dlygate4sd3_1
XFILLER_0_46_29 VGND VGND VPWR VPWR sky130_fd_sc_hd__decap_4
XFILLER_0_87_337 VPWR VGND VPWR VGND sky130_ef_sc_hd__decap_12
XFILLER_0_87_315 VPWR VGND VPWR VGND sky130_ef_sc_hd__decap_12
X_3570_ fifo1.rd_pointer\[2\] fifo1.wr_pointer\[2\] VGND VGND VPWR VPWR _0609_ sky130_fd_sc_hd__and2_1
XFILLER_0_11_87 VGND VGND VPWR VPWR sky130_fd_sc_hd__fill_1
X_2521_ _1399_ _1400_ _1401_ fifo3.soft_reset VGND VGND VPWR VPWR _1402_ sky130_fd_sc_hd__a31oi_1
X_2452_ fifo1.mem\[9\]\[6\] _1296_ VGND VGND VPWR VPWR _1336_ sky130_fd_sc_hd__or2b_1
X_2383_ fifo1.mem\[3\]\[4\] _1220_ _1268_ VGND VGND VPWR VPWR _1269_ sky130_fd_sc_hd__o21ai_1
X_4122_ regis.header_byte\[6\] _0684_ _1020_ _0988_ VGND VGND VPWR VPWR _1021_ sky130_fd_sc_hd__o2bb2a_1
X_4053_ _0766_ _0960_ _0956_ _0969_ VGND VGND VPWR VPWR _0130_ sky130_fd_sc_hd__a31o_1
X_3004_ _1569_ fifo2.mem\[0\]\[6\] _1562_ VGND VGND VPWR VPWR _1706_ sky130_fd_sc_hd__o21ba_1
Xinput3 data_in[2] VGND VGND VPWR VPWR net3 sky130_fd_sc_hd__clkbuf_4
XFILLER_0_59_540 VGND VGND VPWR VPWR sky130_fd_sc_hd__fill_1
X_3906_ _0745_ _0869_ _0871_ _0873_ net51 VGND VGND VPWR VPWR _0079_ sky130_fd_sc_hd__a32o_1
XFILLER_0_46_223 VGND VGND VPWR VPWR sky130_fd_sc_hd__fill_1
X_3837_ _0822_ VGND VGND VPWR VPWR _0061_ sky130_fd_sc_hd__clkbuf_1
XFILLER_0_6_353 VGND VGND VPWR VPWR sky130_fd_sc_hd__decap_3
X_3768_ fifo3.wr_pointer\[1\] fifo3.wr_pointer\[0\] VGND VGND VPWR VPWR _0771_ sky130_fd_sc_hd__and2_1
XFILLER_0_61_237 VGND VGND VPWR VPWR sky130_fd_sc_hd__decap_8
X_2719_ net293 _1481_ _1483_ _0932_ VGND VGND VPWR VPWR _0381_ sky130_fd_sc_hd__a22o_1
Xclkbuf_leaf_23_clock clknet_3_6__leaf_clock VGND VGND VPWR VPWR clknet_leaf_23_clock
+ sky130_fd_sc_hd__clkbuf_16
X_3699_ fsm1.addr\[1\] fsm1.addr\[0\] VGND VGND VPWR VPWR _0720_ sky130_fd_sc_hd__and2b_1
Xclkbuf_leaf_38_clock clknet_3_4__leaf_clock VGND VGND VPWR VPWR clknet_leaf_38_clock
+ sky130_fd_sc_hd__clkbuf_16
XTAP_1013 VGND VPWR sky130_fd_sc_hd__tapvpwrvgnd_1
XTAP_1002 VGND VPWR sky130_fd_sc_hd__tapvpwrvgnd_1
XFILLER_0_69_337 VGND VGND VPWR VPWR sky130_fd_sc_hd__decap_4
XTAP_1046 VGND VPWR sky130_fd_sc_hd__tapvpwrvgnd_1
XTAP_1035 VGND VPWR sky130_fd_sc_hd__tapvpwrvgnd_1
XTAP_1024 VGND VPWR sky130_fd_sc_hd__tapvpwrvgnd_1
XTAP_1068 VGND VPWR sky130_fd_sc_hd__tapvpwrvgnd_1
XTAP_1057 VGND VPWR sky130_fd_sc_hd__tapvpwrvgnd_1
XFILLER_0_37_223 VGND VGND VPWR VPWR sky130_fd_sc_hd__fill_1
XFILLER_0_80_513 VPWR VGND VPWR VGND sky130_ef_sc_hd__decap_12
XFILLER_0_0_518 VPWR VGND VPWR VGND sky130_ef_sc_hd__decap_12
XTAP_808 VGND VPWR sky130_fd_sc_hd__tapvpwrvgnd_1
XTAP_819 VGND VPWR sky130_fd_sc_hd__tapvpwrvgnd_1
XFILLER_0_87_167 VGND VGND VPWR VPWR sky130_fd_sc_hd__fill_1
XFILLER_0_22_20 VGND VGND VPWR VPWR sky130_fd_sc_hd__decap_8
X_4740_ clknet_leaf_52_clock _0546_ VGND VGND VPWR VPWR fifo3.count\[6\] sky130_fd_sc_hd__dfxtp_1
XFILLER_0_83_373 VPWR VGND VPWR VGND sky130_ef_sc_hd__decap_12
XFILLER_0_16_429 VGND VGND VPWR VPWR sky130_fd_sc_hd__decap_3
X_4671_ clknet_leaf_59_clock _0477_ VGND VGND VPWR VPWR fifo3.mem\[9\]\[3\] sky130_fd_sc_hd__dfxtp_1
X_3622_ net9 VGND VGND VPWR VPWR _0660_ sky130_fd_sc_hd__clkbuf_4
X_3553_ _0742_ _2105_ _2103_ _2104_ net344 VGND VGND VPWR VPWR _0593_ sky130_fd_sc_hd__a32o_1
XFILLER_0_51_281 VGND VGND VPWR VPWR sky130_fd_sc_hd__decap_4
X_2504_ _1354_ _1369_ _1370_ _1386_ VGND VGND VPWR VPWR _1387_ sky130_fd_sc_hd__nand4_1
XFILLER_0_11_156 VGND VGND VPWR VPWR sky130_fd_sc_hd__fill_1
X_3484_ _0735_ _2070_ net46 VGND VGND VPWR VPWR _2076_ sky130_fd_sc_hd__and3_1
X_2435_ _1203_ VGND VGND VPWR VPWR _1320_ sky130_fd_sc_hd__clkbuf_4
XFILLER_0_11_178 VPWR VGND VPWR VGND sky130_ef_sc_hd__decap_12
X_4105_ net4 _0986_ _0989_ _1006_ VGND VGND VPWR VPWR _1007_ sky130_fd_sc_hd__o211ai_1
X_2366_ fifo1.mem\[15\]\[3\] _1232_ VGND VGND VPWR VPWR _1253_ sky130_fd_sc_hd__and2b_1
X_2297_ _0002_ VGND VGND VPWR VPWR _1185_ sky130_fd_sc_hd__clkbuf_4
X_4036_ _0713_ _0741_ _0956_ _0959_ net94 VGND VGND VPWR VPWR _0123_ sky130_fd_sc_hd__a32o_1
XFILLER_0_2_85 VGND VGND VPWR VPWR sky130_fd_sc_hd__decap_3
XPHY_107 VGND VGND VPWR VPWR sky130_fd_sc_hd__decap_3
XFILLER_0_66_307 VGND VGND VPWR VPWR sky130_fd_sc_hd__fill_1
XPHY_118 VGND VGND VPWR VPWR sky130_fd_sc_hd__decap_3
XPHY_129 VGND VGND VPWR VPWR sky130_fd_sc_hd__decap_3
XFILLER_0_34_237 VGND VGND VPWR VPWR sky130_fd_sc_hd__decap_4
XFILLER_0_6_183 VGND VGND VPWR VPWR sky130_fd_sc_hd__fill_1
XFILLER_0_42_270 VGND VGND VPWR VPWR sky130_fd_sc_hd__decap_8
Xmax_cap43 net44 VGND VGND VPWR VPWR net43 sky130_fd_sc_hd__buf_1
XPHY_9 VGND VGND VPWR VPWR sky130_fd_sc_hd__decap_3
XFILLER_0_80_343 VPWR VGND VPWR VGND sky130_ef_sc_hd__decap_12
XFILLER_0_0_337 VPWR VGND VPWR VGND sky130_ef_sc_hd__decap_12
XTAP_605 VGND VPWR sky130_fd_sc_hd__tapvpwrvgnd_1
XTAP_616 VGND VPWR sky130_fd_sc_hd__tapvpwrvgnd_1
XTAP_627 VGND VPWR sky130_fd_sc_hd__tapvpwrvgnd_1
XTAP_638 VGND VPWR sky130_fd_sc_hd__tapvpwrvgnd_1
XTAP_649 VGND VPWR sky130_fd_sc_hd__tapvpwrvgnd_1
X_2220_ _0613_ _0748_ fifo1.wr_pointer\[1\] _0749_ VGND VGND VPWR VPWR _1136_ sky130_fd_sc_hd__and4bb_1
XFILLER_0_84_37 VGND VGND VPWR VPWR sky130_fd_sc_hd__fill_1
X_2151_ _1102_ _1101_ VGND VGND VPWR VPWR _1103_ sky130_fd_sc_hd__nor2_4
XFILLER_0_88_410 VGND VGND VPWR VPWR sky130_fd_sc_hd__decap_3
XFILLER_0_17_42 VGND VGND VPWR VPWR sky130_fd_sc_hd__fill_1
X_2984_ _1685_ _1557_ _1686_ VGND VGND VPWR VPWR _1687_ sky130_fd_sc_hd__a21oi_1
XFILLER_0_8_459 VPWR VGND VPWR VGND sky130_ef_sc_hd__decap_12
X_4723_ clknet_leaf_50_clock _0529_ VGND VGND VPWR VPWR fifo3.rd_pointer\[2\] sky130_fd_sc_hd__dfxtp_1
XFILLER_0_56_362 VGND VGND VPWR VPWR sky130_fd_sc_hd__fill_2
XFILLER_0_16_237 VGND VGND VPWR VPWR sky130_fd_sc_hd__decap_4
X_4654_ clknet_leaf_55_clock _0460_ VGND VGND VPWR VPWR fifo3.mem\[14\]\[4\] sky130_fd_sc_hd__dfxtp_1
X_3605_ fifo3.wr_pointer\[1\] fifo3.rd_pointer\[1\] VGND VGND VPWR VPWR _0643_ sky130_fd_sc_hd__or2b_1
XFILLER_0_31_218 VGND VGND VPWR VPWR sky130_fd_sc_hd__decap_6
X_4585_ clknet_leaf_10_clock _0391_ VGND VGND VPWR VPWR fifo1.mem\[11\]\[5\] sky130_fd_sc_hd__dfxtp_1
XFILLER_0_12_432 VPWR VGND VPWR VGND sky130_ef_sc_hd__decap_12
X_3536_ _1772_ _1420_ _1774_ _1775_ fifo3.mem\[11\]\[5\] VGND VGND VPWR VPWR _2099_
+ sky130_fd_sc_hd__o311ai_1
X_3467_ fifo3.count\[6\] _2020_ _2062_ _2025_ _2066_ VGND VGND VPWR VPWR _2067_ sky130_fd_sc_hd__o311a_1
X_2418_ fifo1.mem\[1\]\[5\] VGND VGND VPWR VPWR _1303_ sky130_fd_sc_hd__inv_2
XFILLER_0_58_93 VGND VGND VPWR VPWR sky130_fd_sc_hd__decap_8
X_3398_ _1712_ _1042_ VGND VGND VPWR VPWR _2006_ sky130_fd_sc_hd__and2_1
X_2349_ _1176_ fifo1.mem\[4\]\[3\] _1177_ VGND VGND VPWR VPWR _1236_ sky130_fd_sc_hd__o21bai_1
XFILLER_0_74_92 VGND VGND VPWR VPWR sky130_fd_sc_hd__decap_6
X_4019_ _0930_ _0943_ _0948_ VGND VGND VPWR VPWR _0117_ sky130_fd_sc_hd__o21a_1
XFILLER_0_35_502 VGND VGND VPWR VPWR sky130_fd_sc_hd__fill_2
XFILLER_0_62_365 VGND VGND VPWR VPWR sky130_fd_sc_hd__decap_4
XFILLER_0_30_284 VGND VGND VPWR VPWR sky130_fd_sc_hd__decap_3
XFILLER_0_89_218 VGND VGND VPWR VPWR sky130_fd_sc_hd__decap_6
XFILLER_0_57_104 VGND VGND VPWR VPWR sky130_fd_sc_hd__fill_1
XFILLER_0_57_137 VGND VGND VPWR VPWR sky130_fd_sc_hd__fill_1
XFILLER_0_26_524 VGND VGND VPWR VPWR sky130_fd_sc_hd__decap_8
XFILLER_0_65_181 VGND VGND VPWR VPWR sky130_fd_sc_hd__fill_1
XFILLER_0_13_218 VGND VGND VPWR VPWR sky130_fd_sc_hd__decap_6
Xhold108 fifo1.mem\[0\]\[4\] VGND VGND VPWR VPWR net156 sky130_fd_sc_hd__dlygate4sd3_1
Xhold119 fifo3.mem\[12\]\[7\] VGND VGND VPWR VPWR net167 sky130_fd_sc_hd__dlygate4sd3_1
X_4370_ clknet_leaf_37_clock _0184_ VGND VGND VPWR VPWR fifo2.mem\[15\]\[8\] sky130_fd_sc_hd__dfxtp_1
X_3321_ _1944_ _1946_ _1809_ VGND VGND VPWR VPWR _1947_ sky130_fd_sc_hd__a21oi_2
XFILLER_0_0_167 VGND VGND VPWR VPWR sky130_fd_sc_hd__fill_1
XTAP_402 VGND VPWR sky130_fd_sc_hd__tapvpwrvgnd_1
XTAP_413 VGND VPWR sky130_fd_sc_hd__tapvpwrvgnd_1
XTAP_424 VGND VPWR sky130_fd_sc_hd__tapvpwrvgnd_1
X_3252_ _1828_ fifo3.mem\[8\]\[3\] _1835_ VGND VGND VPWR VPWR _1881_ sky130_fd_sc_hd__o21bai_1
XTAP_435 VGND VPWR sky130_fd_sc_hd__tapvpwrvgnd_1
XTAP_446 VGND VPWR sky130_fd_sc_hd__tapvpwrvgnd_1
XTAP_457 VGND VPWR sky130_fd_sc_hd__tapvpwrvgnd_1
XFILLER_0_28_41 VPWR VGND VPWR VGND sky130_ef_sc_hd__decap_12
X_3183_ _1812_ _1813_ _1814_ VGND VGND VPWR VPWR _1815_ sky130_fd_sc_hd__a21o_1
XTAP_468 VGND VPWR sky130_fd_sc_hd__tapvpwrvgnd_1
XTAP_479 VGND VPWR sky130_fd_sc_hd__tapvpwrvgnd_1
X_2203_ _0747_ _1121_ _1125_ _1127_ VGND VGND VPWR VPWR _0221_ sky130_fd_sc_hd__a31o_1
XFILLER_0_28_85 VGND VGND VPWR VPWR sky130_fd_sc_hd__decap_4
X_2134_ _0748_ _0751_ _0753_ _1094_ VGND VGND VPWR VPWR _1095_ sky130_fd_sc_hd__and4_1
XFILLER_0_88_251 VGND VGND VPWR VPWR sky130_fd_sc_hd__fill_1
XFILLER_0_48_159 VGND VGND VPWR VPWR sky130_fd_sc_hd__decap_3
XFILLER_0_91_405 VPWR VGND VPWR VGND sky130_ef_sc_hd__decap_12
XFILLER_0_17_502 VGND VGND VPWR VPWR sky130_fd_sc_hd__fill_2
XFILLER_0_29_373 VGND VGND VPWR VPWR sky130_fd_sc_hd__fill_1
XFILLER_0_63_118 VGND VGND VPWR VPWR sky130_fd_sc_hd__fill_1
XFILLER_0_91_449 VPWR VGND VPWR VGND sky130_ef_sc_hd__decap_12
XFILLER_0_60_83 VGND VGND VPWR VPWR sky130_fd_sc_hd__fill_1
X_2967_ _1569_ fifo2.mem\[6\]\[5\] _1562_ VGND VGND VPWR VPWR _1670_ sky130_fd_sc_hd__o21ai_1
X_4706_ clknet_leaf_15_clock _0512_ VGND VGND VPWR VPWR fifo1.mem\[14\]\[7\] sky130_fd_sc_hd__dfxtp_1
XFILLER_0_32_505 VGND VGND VPWR VPWR sky130_fd_sc_hd__decap_4
XFILLER_0_60_94 VPWR VGND VPWR VGND sky130_ef_sc_hd__decap_12
X_2898_ fifo2.mem\[3\]\[3\] _1572_ _1602_ VGND VGND VPWR VPWR _1603_ sky130_fd_sc_hd__o21ai_1
X_4637_ clknet_leaf_30_clock _0443_ VGND VGND VPWR VPWR fifo2.count\[3\] sky130_fd_sc_hd__dfxtp_1
XFILLER_0_71_173 VGND VGND VPWR VPWR sky130_fd_sc_hd__fill_1
XFILLER_0_71_195 VGND VGND VPWR VPWR sky130_fd_sc_hd__fill_2
XFILLER_0_4_473 VGND VGND VPWR VPWR sky130_fd_sc_hd__decap_3
XFILLER_0_12_251 VGND VGND VPWR VPWR sky130_fd_sc_hd__fill_1
X_4568_ clknet_leaf_24_clock _0374_ VGND VGND VPWR VPWR fifo2.mem\[5\]\[6\] sky130_fd_sc_hd__dfxtp_1
X_3519_ _1760_ _0840_ _1781_ fifo3.mem\[10\]\[6\] _1783_ VGND VGND VPWR VPWR _2090_
+ sky130_fd_sc_hd__o311a_1
XFILLER_0_5_9 VPWR VGND VPWR VGND sky130_ef_sc_hd__decap_12
X_4499_ clknet_leaf_39_clock _0305_ VGND VGND VPWR VPWR fifo2.mem\[10\]\[0\] sky130_fd_sc_hd__dfxtp_1
XTAP_980 VGND VPWR sky130_fd_sc_hd__tapvpwrvgnd_1
XTAP_991 VGND VPWR sky130_fd_sc_hd__tapvpwrvgnd_1
XFILLER_0_79_251 VGND VGND VPWR VPWR sky130_fd_sc_hd__decap_3
XFILLER_0_39_159 VGND VGND VPWR VPWR sky130_fd_sc_hd__decap_3
XFILLER_0_54_118 VGND VGND VPWR VPWR sky130_fd_sc_hd__decap_4
XFILLER_0_67_479 VGND VGND VPWR VPWR sky130_fd_sc_hd__decap_3
XFILLER_0_23_505 VPWR VGND VPWR VGND sky130_ef_sc_hd__decap_12
XFILLER_0_62_195 VGND VGND VPWR VPWR sky130_fd_sc_hd__fill_1
XFILLER_0_85_287 VGND VGND VPWR VPWR sky130_fd_sc_hd__fill_1
X_3870_ _0743_ _0825_ _0837_ _0836_ net92 VGND VGND VPWR VPWR _0068_ sky130_fd_sc_hd__a32o_1
XFILLER_0_45_129 VPWR VGND VPWR VGND sky130_ef_sc_hd__decap_12
X_2821_ _1256_ _0983_ VGND VGND VPWR VPWR _1532_ sky130_fd_sc_hd__and2_1
X_2752_ _1098_ _1491_ _1492_ net150 VGND VGND VPWR VPWR _0405_ sky130_fd_sc_hd__a22o_1
XFILLER_0_38_192 VGND VGND VPWR VPWR sky130_fd_sc_hd__decap_4
XFILLER_0_26_376 VPWR VGND VPWR VGND sky130_ef_sc_hd__decap_12
X_2683_ _1467_ _1438_ _0962_ fifo2.mem\[2\]\[1\] _0967_ VGND VGND VPWR VPWR _1469_
+ sky130_fd_sc_hd__o311a_1
XFILLER_0_30_97 VGND VGND VPWR VPWR sky130_fd_sc_hd__decap_8
X_4422_ clknet_leaf_7_clock _0236_ VGND VGND VPWR VPWR fifo1.mem\[6\]\[6\] sky130_fd_sc_hd__dfxtp_1
X_4353_ clknet_leaf_45_clock _0167_ VGND VGND VPWR VPWR regis.packet_parity\[0\] sky130_fd_sc_hd__dfxtp_1
X_4284_ clknet_leaf_46_clock _0098_ VGND VGND VPWR VPWR regis.fifo_full_state\[1\]
+ sky130_fd_sc_hd__dfxtp_1
X_3304_ fifo3.mem\[11\]\[5\] _1830_ VGND VGND VPWR VPWR _1931_ sky130_fd_sc_hd__and2b_1
XTAP_210 VGND VPWR sky130_fd_sc_hd__tapvpwrvgnd_1
XTAP_221 VGND VPWR sky130_fd_sc_hd__tapvpwrvgnd_1
XTAP_232 VGND VPWR sky130_fd_sc_hd__tapvpwrvgnd_1
X_3235_ _1804_ VGND VGND VPWR VPWR _1864_ sky130_fd_sc_hd__buf_4
XTAP_265 VGND VPWR sky130_fd_sc_hd__tapvpwrvgnd_1
XTAP_254 VGND VPWR sky130_fd_sc_hd__tapvpwrvgnd_1
XTAP_243 VGND VPWR sky130_fd_sc_hd__tapvpwrvgnd_1
XTAP_298 VGND VPWR sky130_fd_sc_hd__tapvpwrvgnd_1
XTAP_287 VGND VPWR sky130_fd_sc_hd__tapvpwrvgnd_1
XTAP_276 VGND VPWR sky130_fd_sc_hd__tapvpwrvgnd_1
X_3166_ net272 _1801_ _1803_ _0761_ VGND VGND VPWR VPWR _0508_ sky130_fd_sc_hd__a22o_1
X_2117_ regis.packet_parity\[4\] _1082_ regis.internal_parity\[0\] _1060_ VGND VGND
+ VPWR VPWR _1088_ sky130_fd_sc_hd__o2bb2a_1
X_3097_ _0797_ _0838_ _1758_ _1769_ VGND VGND VPWR VPWR _0473_ sky130_fd_sc_hd__a31o_1
XFILLER_0_12_3 VGND VGND VPWR VPWR sky130_fd_sc_hd__fill_1
XFILLER_0_49_424 VGND VGND VPWR VPWR sky130_fd_sc_hd__fill_1
X_3999_ _0934_ _0924_ _0935_ VGND VGND VPWR VPWR _0110_ sky130_fd_sc_hd__a21o_1
XFILLER_0_57_490 VGND VGND VPWR VPWR sky130_fd_sc_hd__decap_8
XFILLER_0_91_279 VGND VGND VPWR VPWR sky130_fd_sc_hd__fill_1
XFILLER_0_29_192 VGND VGND VPWR VPWR sky130_fd_sc_hd__decap_8
XFILLER_0_72_482 VPWR VGND VPWR VGND sky130_ef_sc_hd__decap_12
XFILLER_0_17_387 VGND VGND VPWR VPWR sky130_fd_sc_hd__fill_2
XFILLER_0_44_195 VGND VGND VPWR VPWR sky130_fd_sc_hd__fill_1
XFILLER_0_67_265 VGND VGND VPWR VPWR sky130_fd_sc_hd__fill_1
XFILLER_0_82_235 VGND VGND VPWR VPWR sky130_fd_sc_hd__fill_1
XFILLER_0_35_140 VPWR VGND VPWR VGND sky130_ef_sc_hd__decap_12
XFILLER_0_35_173 VGND VGND VPWR VPWR sky130_fd_sc_hd__decap_8
XFILLER_0_2_229 VGND VGND VPWR VPWR sky130_fd_sc_hd__decap_6
XFILLER_0_23_335 VGND VGND VPWR VPWR sky130_fd_sc_hd__fill_1
XFILLER_0_50_132 VGND VGND VPWR VPWR sky130_fd_sc_hd__fill_1
X_3020_ _1547_ _1548_ VGND VGND VPWR VPWR _1721_ sky130_fd_sc_hd__nand2_1
XFILLER_0_25_20 VGND VGND VPWR VPWR sky130_fd_sc_hd__decap_4
XFILLER_0_25_86 VGND VGND VPWR VPWR sky130_fd_sc_hd__decap_6
X_3922_ syn.count1\[0\] syn.count1\[1\] syn.count1\[2\] VGND VGND VPWR VPWR _0884_
+ sky130_fd_sc_hd__and3_1
X_3853_ net46 VGND VGND VPWR VPWR _0837_ sky130_fd_sc_hd__clkbuf_4
X_2804_ fifo1.mem\[4\]\[0\] fifo1.mem\[5\]\[0\] fifo1.mem\[6\]\[0\] fifo1.mem\[7\]\[0\]
+ _1317_ _1339_ VGND VGND VPWR VPWR _1518_ sky130_fd_sc_hd__mux4_1
X_3784_ _0785_ _0786_ fifo3.mem\[7\]\[0\] VGND VGND VPWR VPWR _0787_ sky130_fd_sc_hd__and3_1
XFILLER_0_26_195 VGND VGND VPWR VPWR sky130_fd_sc_hd__fill_1
XFILLER_0_41_110 VGND VGND VPWR VPWR sky130_fd_sc_hd__fill_2
X_2735_ _0768_ _1485_ _1486_ net171 VGND VGND VPWR VPWR _0394_ sky130_fd_sc_hd__a22o_1
X_2666_ _1109_ _1462_ _1463_ net259 VGND VGND VPWR VPWR _0348_ sky130_fd_sc_hd__a22o_1
X_4405_ clknet_leaf_9_clock _0219_ VGND VGND VPWR VPWR fifo1.mem\[8\]\[7\] sky130_fd_sc_hd__dfxtp_1
X_4336_ clknet_leaf_39_clock _0150_ VGND VGND VPWR VPWR regis.header_byte\[0\] sky130_fd_sc_hd__dfxtp_1
X_2597_ _1435_ _0867_ net318 _0862_ _1426_ VGND VGND VPWR VPWR _0306_ sky130_fd_sc_hd__a32o_1
X_4267_ clknet_leaf_38_clock _0081_ VGND VGND VPWR VPWR fsm1.addr\[1\] sky130_fd_sc_hd__dfxtp_1
X_4198_ regis.packet_parity\[5\] regis.internal_parity\[5\] VGND VGND VPWR VPWR _1070_
+ sky130_fd_sc_hd__or2_1
X_3218_ fifo3.mem\[3\]\[2\] _1830_ VGND VGND VPWR VPWR _1848_ sky130_fd_sc_hd__and2b_1
X_3149_ fifo2.rd_pointer\[3\] _1513_ _1514_ VGND VGND VPWR VPWR _0495_ sky130_fd_sc_hd__a21oi_1
XFILLER_0_69_519 VPWR VGND VPWR VGND sky130_ef_sc_hd__decap_12
XFILLER_0_37_416 VGND VGND VPWR VPWR sky130_fd_sc_hd__decap_8
XFILLER_0_32_110 VPWR VGND VPWR VGND sky130_ef_sc_hd__decap_12
Xhold280 fifo2.mem\[0\]\[5\] VGND VGND VPWR VPWR net328 sky130_fd_sc_hd__dlygate4sd3_1
XFILLER_0_1_3 VPWR VGND VPWR VGND sky130_ef_sc_hd__decap_12
Xhold291 fifo1.mem\[6\]\[3\] VGND VGND VPWR VPWR net339 sky130_fd_sc_hd__dlygate4sd3_1
XFILLER_0_87_327 VGND VGND VPWR VPWR sky130_fd_sc_hd__decap_8
XFILLER_0_87_349 VPWR VGND VPWR VGND sky130_ef_sc_hd__decap_12
XFILLER_0_28_416 VGND VGND VPWR VPWR sky130_fd_sc_hd__decap_4
XFILLER_0_28_449 VGND VGND VPWR VPWR sky130_fd_sc_hd__fill_1
XFILLER_0_55_235 VGND VGND VPWR VPWR sky130_fd_sc_hd__decap_6
XFILLER_0_3_505 VPWR VGND VPWR VGND sky130_ef_sc_hd__decap_12
XFILLER_0_87_15 VPWR VGND VPWR VGND sky130_ef_sc_hd__decap_12
XFILLER_0_23_154 VGND VGND VPWR VPWR sky130_fd_sc_hd__fill_2
X_2520_ fifo3.count\[6\] fifo3.count\[5\] VGND VGND VPWR VPWR _1401_ sky130_fd_sc_hd__nor2_1
X_2451_ _1332_ _1334_ _1187_ VGND VGND VPWR VPWR _1335_ sky130_fd_sc_hd__a21oi_2
Xclkbuf_leaf_4_clock clknet_3_1__leaf_clock VGND VGND VPWR VPWR clknet_leaf_4_clock
+ sky130_fd_sc_hd__clkbuf_16
X_2382_ _1232_ fifo1.mem\[2\]\[4\] _1182_ VGND VGND VPWR VPWR _1268_ sky130_fd_sc_hd__o21a_1
X_4121_ fifo1.lfd_state fifo1.data_in\[6\] VGND VGND VPWR VPWR _1020_ sky130_fd_sc_hd__or2b_1
X_4052_ _0957_ _0961_ _0962_ fifo2.mem\[1\]\[7\] _0967_ VGND VGND VPWR VPWR _0969_
+ sky130_fd_sc_hd__o311a_1
Xinput4 data_in[3] VGND VGND VPWR VPWR net4 sky130_fd_sc_hd__clkbuf_2
XFILLER_0_36_41 VGND VGND VPWR VPWR sky130_fd_sc_hd__fill_2
X_3003_ fifo2.mem\[4\]\[6\] fifo2.mem\[5\]\[6\] fifo2.mem\[6\]\[6\] fifo2.mem\[7\]\[6\]
+ _1557_ _1540_ VGND VGND VPWR VPWR _1705_ sky130_fd_sc_hd__mux4_2
XFILLER_0_36_74 VGND VGND VPWR VPWR sky130_fd_sc_hd__decap_8
XFILLER_0_74_533 VGND VGND VPWR VPWR sky130_fd_sc_hd__decap_8
XFILLER_0_19_449 VPWR VGND VPWR VGND sky130_ef_sc_hd__decap_12
X_3905_ _0744_ _0869_ _0871_ _0873_ net139 VGND VGND VPWR VPWR _0078_ sky130_fd_sc_hd__a32o_1
XFILLER_0_52_73 VGND VGND VPWR VPWR sky130_fd_sc_hd__decap_8
X_3836_ _0821_ _0767_ _0805_ VGND VGND VPWR VPWR _0822_ sky130_fd_sc_hd__mux2_1
XFILLER_0_34_419 VGND VGND VPWR VPWR sky130_fd_sc_hd__fill_1
X_3767_ _0769_ VGND VGND VPWR VPWR _0770_ sky130_fd_sc_hd__clkbuf_4
X_2718_ net343 _1481_ _1483_ _0930_ VGND VGND VPWR VPWR _0380_ sky130_fd_sc_hd__a22o_1
X_3698_ _0718_ VGND VGND VPWR VPWR _0719_ sky130_fd_sc_hd__buf_2
X_2649_ _0763_ _0856_ _1446_ _1457_ VGND VGND VPWR VPWR _0337_ sky130_fd_sc_hd__a31o_1
X_4319_ clknet_leaf_30_clock _0133_ VGND VGND VPWR VPWR fifo2.mem\[0\]\[1\] sky130_fd_sc_hd__dfxtp_1
XTAP_1003 VGND VPWR sky130_fd_sc_hd__tapvpwrvgnd_1
XFILLER_0_69_349 VPWR VGND VPWR VGND sky130_ef_sc_hd__decap_12
XTAP_1047 VGND VPWR sky130_fd_sc_hd__tapvpwrvgnd_1
XTAP_1036 VGND VPWR sky130_fd_sc_hd__tapvpwrvgnd_1
XTAP_1025 VGND VPWR sky130_fd_sc_hd__tapvpwrvgnd_1
XTAP_1014 VGND VPWR sky130_fd_sc_hd__tapvpwrvgnd_1
XTAP_1069 VGND VPWR sky130_fd_sc_hd__tapvpwrvgnd_1
XTAP_1058 VGND VPWR sky130_fd_sc_hd__tapvpwrvgnd_1
XFILLER_0_80_525 VGND VGND VPWR VPWR sky130_fd_sc_hd__decap_6
XTAP_809 VGND VPWR sky130_fd_sc_hd__tapvpwrvgnd_1
XFILLER_0_87_113 VPWR VGND VPWR VGND sky130_ef_sc_hd__decap_12
XFILLER_0_28_213 VPWR VGND VPWR VGND sky130_ef_sc_hd__decap_12
XFILLER_0_83_330 VGND VGND VPWR VPWR sky130_fd_sc_hd__decap_6
XFILLER_0_83_385 VGND VGND VPWR VPWR sky130_fd_sc_hd__decap_6
X_4670_ clknet_leaf_58_clock _0476_ VGND VGND VPWR VPWR fifo3.mem\[9\]\[2\] sky130_fd_sc_hd__dfxtp_1
X_3621_ net1 VGND VGND VPWR VPWR _0659_ sky130_fd_sc_hd__clkbuf_4
X_3552_ _0739_ _2105_ _2103_ _2104_ net311 VGND VGND VPWR VPWR _0592_ sky130_fd_sc_hd__a32o_1
X_2503_ _1372_ _1374_ _1385_ VGND VGND VPWR VPWR _1386_ sky130_fd_sc_hd__a21oi_1
XFILLER_0_11_113 VPWR VGND VPWR VGND sky130_ef_sc_hd__decap_12
XFILLER_0_11_102 VGND VGND VPWR VPWR sky130_fd_sc_hd__fill_1
X_3483_ _2072_ _0783_ net265 _2075_ VGND VGND VPWR VPWR _0553_ sky130_fd_sc_hd__a31o_1
XFILLER_0_51_293 VGND VGND VPWR VPWR sky130_fd_sc_hd__fill_2
X_2434_ _1316_ _1317_ _1318_ VGND VGND VPWR VPWR _1319_ sky130_fd_sc_hd__a21oi_1
X_2365_ _1176_ fifo1.mem\[14\]\[3\] _1178_ VGND VGND VPWR VPWR _1252_ sky130_fd_sc_hd__o21ai_1
X_4104_ regis.fifo_full_state\[3\] _0990_ _0690_ VGND VGND VPWR VPWR _1006_ sky130_fd_sc_hd__o21ba_1
X_2296_ fifo1.mem\[12\]\[8\] fifo1.mem\[13\]\[8\] fifo1.mem\[14\]\[8\] fifo1.mem\[15\]\[8\]
+ _1176_ _1183_ VGND VGND VPWR VPWR _1184_ sky130_fd_sc_hd__mux4_1
X_4035_ _0860_ _0957_ _0716_ _0958_ _0729_ VGND VGND VPWR VPWR _0959_ sky130_fd_sc_hd__o41a_2
XFILLER_0_63_61 VGND VGND VPWR VPWR sky130_fd_sc_hd__fill_1
XPHY_108 VGND VGND VPWR VPWR sky130_fd_sc_hd__decap_3
XPHY_119 VGND VGND VPWR VPWR sky130_fd_sc_hd__decap_3
XFILLER_0_59_393 VGND VGND VPWR VPWR sky130_fd_sc_hd__decap_3
XFILLER_0_74_363 VGND VGND VPWR VPWR sky130_fd_sc_hd__fill_1
XFILLER_0_6_151 VPWR VGND VPWR VGND sky130_ef_sc_hd__decap_12
X_3819_ _0810_ VGND VGND VPWR VPWR _0055_ sky130_fd_sc_hd__clkbuf_1
XFILLER_0_10_190 VGND VGND VPWR VPWR sky130_fd_sc_hd__decap_6
Xmax_cap44 _1509_ VGND VGND VPWR VPWR net44 sky130_fd_sc_hd__buf_1
XFILLER_0_57_308 VGND VGND VPWR VPWR sky130_fd_sc_hd__decap_6
XFILLER_0_69_146 VGND VGND VPWR VPWR sky130_fd_sc_hd__decap_4
XFILLER_0_69_157 VGND VGND VPWR VPWR sky130_fd_sc_hd__fill_2
XFILLER_0_84_138 VGND VGND VPWR VPWR sky130_fd_sc_hd__fill_2
XFILLER_0_38_533 VGND VGND VPWR VPWR sky130_fd_sc_hd__decap_8
XFILLER_0_53_514 VGND VGND VPWR VPWR sky130_fd_sc_hd__fill_2
XFILLER_0_80_355 VGND VGND VPWR VPWR sky130_fd_sc_hd__decap_8
XFILLER_0_0_349 VGND VGND VPWR VPWR sky130_fd_sc_hd__decap_4
XTAP_606 VGND VPWR sky130_fd_sc_hd__tapvpwrvgnd_1
XTAP_617 VGND VPWR sky130_fd_sc_hd__tapvpwrvgnd_1
XTAP_628 VGND VPWR sky130_fd_sc_hd__tapvpwrvgnd_1
XTAP_639 VGND VPWR sky130_fd_sc_hd__tapvpwrvgnd_1
X_2150_ _0756_ VGND VGND VPWR VPWR _1102_ sky130_fd_sc_hd__buf_8
XFILLER_0_88_477 VPWR VGND VPWR VGND sky130_ef_sc_hd__decap_12
Xclkbuf_leaf_22_clock clknet_3_6__leaf_clock VGND VGND VPWR VPWR clknet_leaf_22_clock
+ sky130_fd_sc_hd__clkbuf_16
X_2983_ _1550_ fifo2.mem\[8\]\[5\] _1558_ VGND VGND VPWR VPWR _1686_ sky130_fd_sc_hd__o21bai_1
XFILLER_0_56_341 VGND VGND VPWR VPWR sky130_fd_sc_hd__fill_2
XFILLER_0_16_205 VGND VGND VPWR VPWR sky130_fd_sc_hd__decap_4
X_4722_ clknet_leaf_51_clock _0528_ VGND VGND VPWR VPWR fifo3.rd_pointer\[1\] sky130_fd_sc_hd__dfxtp_2
Xclkbuf_leaf_37_clock clknet_3_4__leaf_clock VGND VGND VPWR VPWR clknet_leaf_37_clock
+ sky130_fd_sc_hd__clkbuf_16
X_4653_ clknet_leaf_49_clock _0459_ VGND VGND VPWR VPWR fifo3.mem\[14\]\[3\] sky130_fd_sc_hd__dfxtp_1
X_3604_ fifo3.rd_pointer\[2\] fifo3.wr_pointer\[2\] VGND VGND VPWR VPWR _0642_ sky130_fd_sc_hd__and2_1
X_4584_ clknet_leaf_10_clock _0390_ VGND VGND VPWR VPWR fifo1.mem\[11\]\[4\] sky130_fd_sc_hd__dfxtp_1
X_3535_ _0738_ _2094_ _2098_ net233 VGND VGND VPWR VPWR _0582_ sky130_fd_sc_hd__a22o_1
XFILLER_0_3_165 VGND VGND VPWR VPWR sky130_fd_sc_hd__decap_3
XFILLER_0_12_477 VPWR VGND VPWR VGND sky130_ef_sc_hd__decap_12
X_3466_ _2049_ fifo3.count\[5\] _2020_ fifo3.count\[6\] VGND VGND VPWR VPWR _2066_
+ sky130_fd_sc_hd__o31ai_1
XFILLER_0_58_50 VGND VGND VPWR VPWR sky130_fd_sc_hd__decap_4
X_2417_ _1298_ _1301_ _1185_ VGND VGND VPWR VPWR _1302_ sky130_fd_sc_hd__o21ai_2
X_3397_ _2005_ VGND VGND VPWR VPWR _0537_ sky130_fd_sc_hd__clkbuf_1
X_2348_ fifo1.mem\[7\]\[3\] _1188_ VGND VGND VPWR VPWR _1235_ sky130_fd_sc_hd__and2b_1
X_2279_ _0693_ VGND VGND VPWR VPWR _1169_ sky130_fd_sc_hd__clkbuf_4
X_4018_ fifo3.mem\[6\]\[3\] _0944_ _0942_ VGND VGND VPWR VPWR _0948_ sky130_fd_sc_hd__a21bo_1
XFILLER_0_22_219 VGND VGND VPWR VPWR sky130_fd_sc_hd__fill_2
XFILLER_0_38_363 VGND VGND VPWR VPWR sky130_fd_sc_hd__fill_1
XFILLER_0_79_38 VGND VGND VPWR VPWR sky130_fd_sc_hd__fill_1
Xhold109 fifo2.mem\[3\]\[4\] VGND VGND VPWR VPWR net157 sky130_fd_sc_hd__dlygate4sd3_1
X_3320_ fifo3.mem\[11\]\[6\] _1942_ _1945_ VGND VGND VPWR VPWR _1946_ sky130_fd_sc_hd__o21ai_1
XFILLER_0_0_113 VPWR VGND VPWR VGND sky130_ef_sc_hd__decap_12
XTAP_403 VGND VPWR sky130_fd_sc_hd__tapvpwrvgnd_1
XTAP_414 VGND VPWR sky130_fd_sc_hd__tapvpwrvgnd_1
X_3251_ fifo3.mem\[11\]\[3\] _1830_ VGND VGND VPWR VPWR _1880_ sky130_fd_sc_hd__and2b_1
XTAP_425 VGND VPWR sky130_fd_sc_hd__tapvpwrvgnd_1
XTAP_436 VGND VPWR sky130_fd_sc_hd__tapvpwrvgnd_1
XTAP_447 VGND VPWR sky130_fd_sc_hd__tapvpwrvgnd_1
XTAP_458 VGND VPWR sky130_fd_sc_hd__tapvpwrvgnd_1
X_3182_ _0011_ VGND VGND VPWR VPWR _1814_ sky130_fd_sc_hd__buf_4
XFILLER_0_28_53 VGND VGND VPWR VPWR sky130_fd_sc_hd__decap_3
XTAP_469 VGND VPWR sky130_fd_sc_hd__tapvpwrvgnd_1
X_2202_ _1126_ _1120_ fifo1.mem\[7\]\[0\] VGND VGND VPWR VPWR _1127_ sky130_fd_sc_hd__and3_1
X_2133_ _0749_ _0613_ VGND VGND VPWR VPWR _1094_ sky130_fd_sc_hd__and2b_1
XFILLER_0_88_241 VGND VGND VPWR VPWR sky130_fd_sc_hd__fill_1
XFILLER_0_44_85 VPWR VGND VPWR VGND sky130_ef_sc_hd__decap_12
XFILLER_0_76_447 VGND VGND VPWR VPWR sky130_fd_sc_hd__fill_1
XFILLER_0_91_417 VGND VGND VPWR VPWR sky130_fd_sc_hd__decap_3
XFILLER_0_8_224 VPWR VGND VPWR VGND sky130_ef_sc_hd__decap_12
XFILLER_0_29_341 VGND VGND VPWR VPWR sky130_fd_sc_hd__fill_1
XFILLER_0_8_279 VGND VGND VPWR VPWR sky130_fd_sc_hd__decap_4
X_2966_ _1539_ VGND VGND VPWR VPWR _1669_ sky130_fd_sc_hd__clkbuf_8
X_4705_ clknet_leaf_15_clock _0511_ VGND VGND VPWR VPWR fifo1.mem\[14\]\[6\] sky130_fd_sc_hd__dfxtp_1
X_2897_ _1556_ fifo2.mem\[2\]\[3\] _1558_ VGND VGND VPWR VPWR _1602_ sky130_fd_sc_hd__o21a_1
X_4636_ clknet_leaf_30_clock _0442_ VGND VGND VPWR VPWR fifo2.count\[2\] sky130_fd_sc_hd__dfxtp_1
XFILLER_0_8_41 VPWR VGND VPWR VGND sky130_ef_sc_hd__decap_12
XFILLER_0_8_85 VGND VGND VPWR VPWR sky130_fd_sc_hd__fill_1
X_4567_ clknet_leaf_21_clock _0373_ VGND VGND VPWR VPWR fifo2.mem\[5\]\[5\] sky130_fd_sc_hd__dfxtp_1
XFILLER_0_12_296 VGND VGND VPWR VPWR sky130_fd_sc_hd__fill_2
XFILLER_0_12_285 VGND VGND VPWR VPWR sky130_fd_sc_hd__fill_1
X_3518_ _0740_ _2084_ _2087_ net221 VGND VGND VPWR VPWR _0574_ sky130_fd_sc_hd__a22o_1
Xclkbuf_3_1__f_clock clknet_0_clock VGND VGND VPWR VPWR clknet_3_1__leaf_clock sky130_fd_sc_hd__clkbuf_16
X_4498_ clknet_leaf_38_clock _0304_ VGND VGND VPWR VPWR fifo2.mem\[12\]\[8\] sky130_fd_sc_hd__dfxtp_1
X_3449_ _2036_ fifo3.count\[3\] _2020_ fifo3.count\[4\] VGND VGND VPWR VPWR _2051_
+ sky130_fd_sc_hd__o31ai_1
XTAP_970 VGND VPWR sky130_fd_sc_hd__tapvpwrvgnd_1
XTAP_992 VGND VPWR sky130_fd_sc_hd__tapvpwrvgnd_1
XTAP_981 VGND VPWR sky130_fd_sc_hd__tapvpwrvgnd_1
XFILLER_0_47_193 VGND VGND VPWR VPWR sky130_fd_sc_hd__fill_2
XFILLER_0_23_517 VPWR VGND VPWR VGND sky130_ef_sc_hd__decap_12
XFILLER_0_85_222 VGND VGND VPWR VPWR sky130_fd_sc_hd__fill_2
X_2820_ _1181_ _1352_ _0996_ _1353_ VGND VGND VPWR VPWR _0434_ sky130_fd_sc_hd__o211a_1
X_2751_ _1110_ _1491_ _1492_ net72 VGND VGND VPWR VPWR _0404_ sky130_fd_sc_hd__a22o_1
XFILLER_0_14_506 VPWR VGND VPWR VGND sky130_ef_sc_hd__decap_12
XFILLER_0_26_333 VGND VGND VPWR VPWR sky130_fd_sc_hd__decap_6
X_2682_ _0747_ _0960_ _1436_ _1468_ VGND VGND VPWR VPWR _0359_ sky130_fd_sc_hd__a31o_1
XFILLER_0_26_388 VPWR VGND VPWR VGND sky130_ef_sc_hd__decap_12
XFILLER_0_53_174 VPWR VGND VPWR VGND sky130_ef_sc_hd__decap_12
X_4421_ clknet_leaf_8_clock _0235_ VGND VGND VPWR VPWR fifo1.mem\[6\]\[5\] sky130_fd_sc_hd__dfxtp_1
X_4352_ clknet_leaf_45_clock _0166_ VGND VGND VPWR VPWR regis.internal_parity\[7\]
+ sky130_fd_sc_hd__dfxtp_1
X_3303_ _1828_ fifo3.mem\[10\]\[5\] _1806_ VGND VGND VPWR VPWR _1930_ sky130_fd_sc_hd__o21ai_1
XTAP_200 VGND VPWR sky130_fd_sc_hd__tapvpwrvgnd_1
XTAP_211 VGND VPWR sky130_fd_sc_hd__tapvpwrvgnd_1
XTAP_222 VGND VPWR sky130_fd_sc_hd__tapvpwrvgnd_1
XTAP_233 VGND VPWR sky130_fd_sc_hd__tapvpwrvgnd_1
X_4283_ clknet_leaf_42_clock _0097_ VGND VGND VPWR VPWR regis.fifo_full_state\[0\]
+ sky130_fd_sc_hd__dfxtp_1
XFILLER_0_39_74 VGND VGND VPWR VPWR sky130_fd_sc_hd__fill_1
XTAP_266 VGND VPWR sky130_fd_sc_hd__tapvpwrvgnd_1
XTAP_255 VGND VPWR sky130_fd_sc_hd__tapvpwrvgnd_1
XTAP_244 VGND VPWR sky130_fd_sc_hd__tapvpwrvgnd_1
X_3234_ fifo3.mem\[5\]\[3\] VGND VGND VPWR VPWR _1863_ sky130_fd_sc_hd__inv_2
XTAP_299 VGND VPWR sky130_fd_sc_hd__tapvpwrvgnd_1
XTAP_288 VGND VPWR sky130_fd_sc_hd__tapvpwrvgnd_1
XTAP_277 VGND VPWR sky130_fd_sc_hd__tapvpwrvgnd_1
X_3165_ net110 _1801_ _1803_ _0760_ VGND VGND VPWR VPWR _0507_ sky130_fd_sc_hd__a22o_1
X_2116_ _1060_ regis.internal_parity\[0\] VGND VGND VPWR VPWR _1087_ sky130_fd_sc_hd__and2_1
X_3096_ _1759_ _1419_ _0835_ _0782_ fifo3.mem\[2\]\[8\] VGND VGND VPWR VPWR _1769_
+ sky130_fd_sc_hd__o311a_1
XFILLER_0_76_277 VGND VGND VPWR VPWR sky130_fd_sc_hd__decap_3
XFILLER_0_64_417 VGND VGND VPWR VPWR sky130_fd_sc_hd__decap_3
XFILLER_0_71_61 VGND VGND VPWR VPWR sky130_fd_sc_hd__fill_1
X_3998_ _0928_ _0786_ fifo3.mem\[5\]\[5\] VGND VGND VPWR VPWR _0935_ sky130_fd_sc_hd__and3_1
XFILLER_0_71_94 VGND VGND VPWR VPWR sky130_fd_sc_hd__decap_3
XFILLER_0_44_141 VPWR VGND VPWR VGND sky130_ef_sc_hd__decap_12
X_2949_ _1649_ _1650_ _1651_ _1652_ VGND VGND VPWR VPWR _1653_ sky130_fd_sc_hd__o22ai_2
XFILLER_0_72_494 VPWR VGND VPWR VGND sky130_ef_sc_hd__decap_12
XFILLER_0_32_369 VGND VGND VPWR VPWR sky130_fd_sc_hd__fill_1
X_4619_ clknet_leaf_35_clock _0425_ VGND VGND VPWR VPWR fifo2.wr_pointer\[3\] sky130_fd_sc_hd__dfxtp_4
XFILLER_0_27_119 VPWR VGND VPWR VGND sky130_ef_sc_hd__decap_12
XFILLER_0_82_269 VPWR VGND VPWR VGND sky130_ef_sc_hd__decap_12
XFILLER_0_35_152 VGND VGND VPWR VPWR sky130_fd_sc_hd__fill_1
XFILLER_0_86_531 VGND VGND VPWR VPWR sky130_fd_sc_hd__fill_1
X_3921_ syn.count1\[0\] syn.count1\[1\] syn.count1\[2\] VGND VGND VPWR VPWR _0883_
+ sky130_fd_sc_hd__a21oi_1
XFILLER_0_18_119 VGND VGND VPWR VPWR sky130_fd_sc_hd__decap_8
X_3852_ _0713_ _0825_ _0830_ _0836_ net73 VGND VGND VPWR VPWR _0062_ sky130_fd_sc_hd__a32o_1
XFILLER_0_6_503 VPWR VGND VPWR VGND sky130_ef_sc_hd__decap_12
X_2803_ _1517_ VGND VGND VPWR VPWR _0431_ sky130_fd_sc_hd__clkbuf_1
X_3783_ _0781_ VGND VGND VPWR VPWR _0786_ sky130_fd_sc_hd__buf_2
X_2734_ _1109_ _1485_ _1486_ net228 VGND VGND VPWR VPWR _0393_ sky130_fd_sc_hd__a22o_1
X_2665_ _1108_ _1462_ _1463_ net112 VGND VGND VPWR VPWR _0347_ sky130_fd_sc_hd__a22o_1
XFILLER_0_1_241 VGND VGND VPWR VPWR sky130_fd_sc_hd__fill_1
X_2596_ _1435_ _0867_ net321 _0861_ _1436_ VGND VGND VPWR VPWR _0305_ sky130_fd_sc_hd__a32o_1
X_4404_ clknet_leaf_10_clock _0218_ VGND VGND VPWR VPWR fifo1.mem\[8\]\[6\] sky130_fd_sc_hd__dfxtp_1
X_4335_ clknet_leaf_42_clock _0149_ VGND VGND VPWR VPWR fifo1.data_in\[7\] sky130_fd_sc_hd__dfxtp_1
XFILLER_0_5_53 VGND VGND VPWR VPWR sky130_fd_sc_hd__decap_3
XFILLER_0_5_97 VGND VGND VPWR VPWR sky130_fd_sc_hd__fill_1
X_4266_ clknet_leaf_39_clock _0080_ VGND VGND VPWR VPWR fsm1.addr\[0\] sky130_fd_sc_hd__dfxtp_1
X_4197_ _0660_ fsm1.rst_int_reg VGND VGND VPWR VPWR _1069_ sky130_fd_sc_hd__and2b_1
X_3217_ _1846_ fifo3.mem\[2\]\[2\] _1806_ VGND VGND VPWR VPWR _1847_ sky130_fd_sc_hd__o21ai_1
X_3148_ fifo2.rd_pointer\[2\] _1509_ _1512_ VGND VGND VPWR VPWR _0494_ sky130_fd_sc_hd__a21oi_1
XFILLER_0_89_391 VGND VGND VPWR VPWR sky130_fd_sc_hd__fill_1
X_3079_ _1759_ VGND VGND VPWR VPWR _1760_ sky130_fd_sc_hd__clkbuf_4
XFILLER_0_64_269 VGND VGND VPWR VPWR sky130_fd_sc_hd__decap_8
XFILLER_0_32_122 VGND VGND VPWR VPWR sky130_fd_sc_hd__decap_4
XFILLER_0_32_166 VGND VGND VPWR VPWR sky130_fd_sc_hd__decap_3
XFILLER_0_20_317 VGND VGND VPWR VPWR sky130_fd_sc_hd__fill_1
XFILLER_0_32_177 VGND VGND VPWR VPWR sky130_fd_sc_hd__decap_3
XFILLER_0_32_188 VGND VGND VPWR VPWR sky130_fd_sc_hd__fill_2
XFILLER_0_13_391 VGND VGND VPWR VPWR sky130_fd_sc_hd__fill_1
Xhold270 fifo2.mem\[10\]\[1\] VGND VGND VPWR VPWR net318 sky130_fd_sc_hd__dlygate4sd3_1
Xhold292 syn.count2\[0\] VGND VGND VPWR VPWR net340 sky130_fd_sc_hd__dlygate4sd3_1
Xhold281 fifo2.mem\[10\]\[6\] VGND VGND VPWR VPWR net329 sky130_fd_sc_hd__dlygate4sd3_1
XFILLER_0_68_531 VGND VGND VPWR VPWR sky130_fd_sc_hd__fill_1
XFILLER_0_3_517 VPWR VGND VPWR VGND sky130_ef_sc_hd__decap_12
XFILLER_0_87_27 VPWR VGND VPWR VGND sky130_ef_sc_hd__decap_12
X_2450_ fifo1.mem\[15\]\[6\] _1320_ _1333_ VGND VGND VPWR VPWR _1334_ sky130_fd_sc_hd__o21ai_1
XFILLER_0_11_328 VGND VGND VPWR VPWR sky130_fd_sc_hd__decap_8
X_2381_ _1220_ fifo1.mem\[1\]\[4\] _1266_ VGND VGND VPWR VPWR _1267_ sky130_fd_sc_hd__o21ai_1
X_4120_ net7 _0986_ _0989_ _1018_ VGND VGND VPWR VPWR _1019_ sky130_fd_sc_hd__o211ai_1
X_4051_ _0743_ _0741_ _0956_ _0959_ net82 VGND VGND VPWR VPWR _0129_ sky130_fd_sc_hd__a32o_1
Xinput5 data_in[4] VGND VGND VPWR VPWR net5 sky130_fd_sc_hd__clkbuf_2
X_3002_ _1703_ _1623_ VGND VGND VPWR VPWR _1704_ sky130_fd_sc_hd__nand2_1
XFILLER_0_78_317 VPWR VGND VPWR VGND sky130_ef_sc_hd__decap_12
XFILLER_0_74_501 VGND VGND VPWR VPWR sky130_fd_sc_hd__decap_3
X_3904_ _0716_ _0726_ _0727_ _0872_ _0729_ VGND VGND VPWR VPWR _0873_ sky130_fd_sc_hd__o41a_1
X_3835_ _0779_ fifo3.mem\[8\]\[8\] _0800_ VGND VGND VPWR VPWR _0821_ sky130_fd_sc_hd__and3_1
X_3766_ fifo3.wr_pointer\[2\] VGND VGND VPWR VPWR _0769_ sky130_fd_sc_hd__buf_4
X_2717_ net289 _1481_ _1483_ _0927_ VGND VGND VPWR VPWR _0379_ sky130_fd_sc_hd__a22o_1
XFILLER_0_42_442 VGND VGND VPWR VPWR sky130_fd_sc_hd__fill_1
XFILLER_0_72_3 VGND VGND VPWR VPWR sky130_fd_sc_hd__fill_1
XFILLER_0_14_166 VGND VGND VPWR VPWR sky130_fd_sc_hd__decap_4
XFILLER_0_42_475 VGND VGND VPWR VPWR sky130_fd_sc_hd__fill_1
X_3697_ fifo2.soft_reset net13 VGND VGND VPWR VPWR _0718_ sky130_fd_sc_hd__and2b_1
X_2648_ _1447_ _1448_ _1450_ _1451_ fifo2.mem\[7\]\[5\] VGND VGND VPWR VPWR _1457_
+ sky130_fd_sc_hd__o311a_1
X_2579_ _0738_ _0955_ _1433_ _1432_ net102 VGND VGND VPWR VPWR _0291_ sky130_fd_sc_hd__a32o_1
X_4318_ clknet_leaf_28_clock _0132_ VGND VGND VPWR VPWR fifo2.mem\[0\]\[0\] sky130_fd_sc_hd__dfxtp_1
X_4249_ clknet_leaf_3_clock _0063_ VGND VGND VPWR VPWR fifo3.mem\[1\]\[1\] sky130_fd_sc_hd__dfxtp_1
XTAP_1004 VGND VPWR sky130_fd_sc_hd__tapvpwrvgnd_1
XTAP_1037 VGND VPWR sky130_fd_sc_hd__tapvpwrvgnd_1
XTAP_1026 VGND VPWR sky130_fd_sc_hd__tapvpwrvgnd_1
XTAP_1015 VGND VPWR sky130_fd_sc_hd__tapvpwrvgnd_1
XTAP_1059 VGND VPWR sky130_fd_sc_hd__tapvpwrvgnd_1
XTAP_1048 VGND VPWR sky130_fd_sc_hd__tapvpwrvgnd_1
XFILLER_0_37_247 VGND VGND VPWR VPWR sky130_fd_sc_hd__decap_3
XFILLER_0_33_420 VGND VGND VPWR VPWR sky130_fd_sc_hd__decap_6
XFILLER_0_87_125 VGND VGND VPWR VPWR sky130_fd_sc_hd__decap_3
XFILLER_0_68_361 VGND VGND VPWR VPWR sky130_fd_sc_hd__decap_3
XFILLER_0_16_409 VGND VGND VPWR VPWR sky130_fd_sc_hd__fill_1
XFILLER_0_43_217 VGND VGND VPWR VPWR sky130_fd_sc_hd__decap_6
XFILLER_0_71_537 VGND VGND VPWR VPWR sky130_fd_sc_hd__decap_4
X_3620_ net2 VGND VGND VPWR VPWR _0658_ sky130_fd_sc_hd__clkbuf_4
X_3551_ _0737_ _2105_ _2103_ _2104_ net255 VGND VGND VPWR VPWR _0591_ sky130_fd_sc_hd__a32o_1
X_2502_ _1200_ _1379_ _1384_ _1181_ VGND VGND VPWR VPWR _1385_ sky130_fd_sc_hd__o211a_1
XFILLER_0_11_125 VGND VGND VPWR VPWR sky130_fd_sc_hd__decap_4
X_3482_ _0733_ _2070_ net45 VGND VGND VPWR VPWR _2075_ sky130_fd_sc_hd__and3_1
XFILLER_0_11_169 VGND VGND VPWR VPWR sky130_fd_sc_hd__decap_4
X_2433_ _1296_ fifo1.mem\[8\]\[5\] _1233_ VGND VGND VPWR VPWR _1318_ sky130_fd_sc_hd__o21bai_1
X_2364_ fifo1.mem\[13\]\[3\] _1188_ VGND VGND VPWR VPWR _1251_ sky130_fd_sc_hd__and2b_1
X_4103_ _1002_ _1004_ _1005_ VGND VGND VPWR VPWR _0144_ sky130_fd_sc_hd__a21boi_1
XFILLER_0_47_63 VGND VGND VPWR VPWR sky130_fd_sc_hd__fill_1
X_2295_ _1182_ VGND VGND VPWR VPWR _1183_ sky130_fd_sc_hd__clkbuf_4
X_4034_ _0624_ _0625_ _0626_ _0627_ _0852_ VGND VGND VPWR VPWR _0958_ sky130_fd_sc_hd__a41o_2
XFILLER_0_78_103 VPWR VGND VPWR VGND sky130_ef_sc_hd__decap_12
XPHY_109 VGND VGND VPWR VPWR sky130_fd_sc_hd__decap_3
XFILLER_0_59_383 VGND VGND VPWR VPWR sky130_fd_sc_hd__decap_4
XFILLER_0_74_342 VGND VGND VPWR VPWR sky130_fd_sc_hd__fill_1
XFILLER_0_62_504 VGND VGND VPWR VPWR sky130_fd_sc_hd__fill_1
XFILLER_0_6_141 VGND VGND VPWR VPWR sky130_fd_sc_hd__decap_4
XFILLER_0_6_130 VGND VGND VPWR VPWR sky130_fd_sc_hd__fill_1
X_3818_ _0809_ _0733_ _0805_ VGND VGND VPWR VPWR _0810_ sky130_fd_sc_hd__mux2_1
XFILLER_0_15_431 VGND VGND VPWR VPWR sky130_fd_sc_hd__fill_1
X_4798_ clknet_leaf_48_clock _0604_ VGND VGND VPWR VPWR fifo3.mem\[13\]\[8\] sky130_fd_sc_hd__dfxtp_1
XFILLER_0_6_163 VPWR VGND VPWR VGND sky130_ef_sc_hd__decap_12
X_3749_ _0759_ _0755_ _0758_ net183 VGND VGND VPWR VPWR _0036_ sky130_fd_sc_hd__a22o_1
XFILLER_0_30_445 VGND VGND VPWR VPWR sky130_fd_sc_hd__decap_4
XFILLER_0_30_456 VGND VGND VPWR VPWR sky130_fd_sc_hd__decap_8
Xmax_cap45 net46 VGND VGND VPWR VPWR net45 sky130_fd_sc_hd__buf_1
Xclkbuf_leaf_3_clock clknet_3_1__leaf_clock VGND VGND VPWR VPWR clknet_leaf_3_clock
+ sky130_fd_sc_hd__clkbuf_16
XFILLER_0_84_106 VGND VGND VPWR VPWR sky130_fd_sc_hd__decap_3
XFILLER_0_38_501 VPWR VGND VPWR VGND sky130_ef_sc_hd__decap_12
XFILLER_0_25_206 VGND VGND VPWR VPWR sky130_fd_sc_hd__decap_8
XTAP_607 VGND VPWR sky130_fd_sc_hd__tapvpwrvgnd_1
XTAP_618 VGND VPWR sky130_fd_sc_hd__tapvpwrvgnd_1
XTAP_629 VGND VPWR sky130_fd_sc_hd__tapvpwrvgnd_1
XFILLER_0_88_401 VGND VGND VPWR VPWR sky130_fd_sc_hd__fill_2
XFILLER_0_17_66 VGND VGND VPWR VPWR sky130_fd_sc_hd__decap_4
XFILLER_0_88_445 VPWR VGND VPWR VGND sky130_ef_sc_hd__decap_12
XFILLER_0_48_309 VGND VGND VPWR VPWR sky130_fd_sc_hd__fill_1
XFILLER_0_88_489 VPWR VGND VPWR VGND sky130_ef_sc_hd__decap_12
XFILLER_0_75_117 VPWR VGND VPWR VGND sky130_ef_sc_hd__decap_12
XFILLER_0_75_106 VGND VGND VPWR VPWR sky130_fd_sc_hd__fill_2
X_2982_ fifo2.mem\[9\]\[5\] VGND VGND VPWR VPWR _1685_ sky130_fd_sc_hd__inv_2
XFILLER_0_90_109 VPWR VGND VPWR VGND sky130_ef_sc_hd__decap_12
X_4721_ clknet_leaf_51_clock _0527_ VGND VGND VPWR VPWR fifo3.rd_pointer\[0\] sky130_fd_sc_hd__dfxtp_1
X_4652_ clknet_leaf_56_clock _0458_ VGND VGND VPWR VPWR fifo3.mem\[14\]\[2\] sky130_fd_sc_hd__dfxtp_1
X_3603_ fifo3.rd_pointer\[2\] fifo3.wr_pointer\[2\] VGND VGND VPWR VPWR _0641_ sky130_fd_sc_hd__nor2_1
X_4583_ clknet_leaf_9_clock _0389_ VGND VGND VPWR VPWR fifo1.mem\[11\]\[3\] sky130_fd_sc_hd__dfxtp_1
X_3534_ _0736_ _2094_ _2098_ net93 VGND VGND VPWR VPWR _0581_ sky130_fd_sc_hd__a22o_1
XFILLER_0_12_489 VGND VGND VPWR VPWR sky130_fd_sc_hd__decap_8
X_3465_ _2061_ _2064_ _2065_ VGND VGND VPWR VPWR _0545_ sky130_fd_sc_hd__a21oi_1
X_2416_ _1299_ _1295_ _1300_ VGND VGND VPWR VPWR _1301_ sky130_fd_sc_hd__a21oi_1
X_3396_ _1697_ _1698_ _1169_ VGND VGND VPWR VPWR _2005_ sky130_fd_sc_hd__and3_2
XFILLER_0_35_3 VGND VGND VPWR VPWR sky130_fd_sc_hd__decap_8
X_2347_ _1232_ fifo1.mem\[6\]\[3\] _1233_ VGND VGND VPWR VPWR _1234_ sky130_fd_sc_hd__o21ai_1
X_2278_ fifo1.rd_pointer\[1\] _1155_ _1160_ _1167_ VGND VGND VPWR VPWR _1168_ sky130_fd_sc_hd__and4_1
X_4017_ _0927_ _0943_ _0947_ VGND VGND VPWR VPWR _0116_ sky130_fd_sc_hd__o21a_1
XFILLER_0_66_106 VGND VGND VPWR VPWR sky130_fd_sc_hd__fill_2
XFILLER_0_47_364 VGND VGND VPWR VPWR sky130_fd_sc_hd__decap_3
XFILLER_0_7_483 VGND VGND VPWR VPWR sky130_fd_sc_hd__fill_2
XFILLER_0_53_334 VGND VGND VPWR VPWR sky130_fd_sc_hd__fill_2
XFILLER_0_0_125 VPWR VGND VPWR VGND sky130_ef_sc_hd__decap_12
XFILLER_0_0_169 VPWR VGND VPWR VGND sky130_ef_sc_hd__decap_12
XFILLER_0_0_147 VPWR VGND VPWR VGND sky130_ef_sc_hd__decap_12
XFILLER_0_21_275 VGND VGND VPWR VPWR sky130_fd_sc_hd__decap_4
XTAP_404 VGND VPWR sky130_fd_sc_hd__tapvpwrvgnd_1
XTAP_415 VGND VPWR sky130_fd_sc_hd__tapvpwrvgnd_1
X_3250_ _1828_ fifo3.mem\[10\]\[3\] _1806_ VGND VGND VPWR VPWR _1879_ sky130_fd_sc_hd__o21ai_1
XTAP_426 VGND VPWR sky130_fd_sc_hd__tapvpwrvgnd_1
XTAP_437 VGND VPWR sky130_fd_sc_hd__tapvpwrvgnd_1
XTAP_448 VGND VPWR sky130_fd_sc_hd__tapvpwrvgnd_1
XTAP_459 VGND VPWR sky130_fd_sc_hd__tapvpwrvgnd_1
X_3181_ fifo3.mem\[0\]\[0\] fifo3.mem\[1\]\[0\] fifo3.mem\[2\]\[0\] fifo3.mem\[3\]\[0\]
+ _1805_ _1807_ VGND VGND VPWR VPWR _1813_ sky130_fd_sc_hd__mux4_1
X_2201_ _0613_ _0749_ _1122_ _1123_ VGND VGND VPWR VPWR _1126_ sky130_fd_sc_hd__nand4b_4
X_2132_ net247 _1091_ _1093_ _0939_ VGND VGND VPWR VPWR _0184_ sky130_fd_sc_hd__a22o_1
XFILLER_0_88_253 VPWR VGND VPWR VGND sky130_ef_sc_hd__decap_12
XFILLER_0_76_437 VGND VGND VPWR VPWR sky130_fd_sc_hd__fill_2
XFILLER_0_44_97 VGND VGND VPWR VPWR sky130_fd_sc_hd__decap_6
XFILLER_0_63_109 VGND VGND VPWR VPWR sky130_fd_sc_hd__decap_3
XFILLER_0_91_429 VGND VGND VPWR VPWR sky130_fd_sc_hd__fill_1
X_4704_ clknet_leaf_14_clock _0510_ VGND VGND VPWR VPWR fifo1.mem\[14\]\[5\] sky130_fd_sc_hd__dfxtp_1
XFILLER_0_60_41 VGND VGND VPWR VPWR sky130_fd_sc_hd__decap_6
X_2965_ fifo2.mem\[7\]\[5\] VGND VGND VPWR VPWR _1668_ sky130_fd_sc_hd__inv_2
XFILLER_0_56_194 VGND VGND VPWR VPWR sky130_fd_sc_hd__fill_2
X_2896_ _1572_ fifo2.mem\[1\]\[3\] _1600_ VGND VGND VPWR VPWR _1601_ sky130_fd_sc_hd__o21ai_1
X_4635_ clknet_leaf_30_clock _0441_ VGND VGND VPWR VPWR fifo2.count\[1\] sky130_fd_sc_hd__dfxtp_1
XFILLER_0_8_53 VPWR VGND VPWR VGND sky130_ef_sc_hd__decap_12
X_4566_ clknet_leaf_21_clock _0372_ VGND VGND VPWR VPWR fifo2.mem\[5\]\[4\] sky130_fd_sc_hd__dfxtp_1
X_3517_ _0932_ _2084_ _2089_ VGND VGND VPWR VPWR _0573_ sky130_fd_sc_hd__a21o_1
X_4497_ clknet_leaf_37_clock _0303_ VGND VGND VPWR VPWR fifo2.mem\[12\]\[7\] sky130_fd_sc_hd__dfxtp_1
X_3448_ _2020_ _2049_ VGND VGND VPWR VPWR _2050_ sky130_fd_sc_hd__or2_1
XTAP_971 VGND VPWR sky130_fd_sc_hd__tapvpwrvgnd_1
XTAP_960 VGND VPWR sky130_fd_sc_hd__tapvpwrvgnd_1
X_3379_ fifo2.mem\[12\]\[0\] fifo2.mem\[13\]\[0\] fifo2.mem\[14\]\[0\] fifo2.mem\[15\]\[0\]
+ _1669_ _1702_ VGND VGND VPWR VPWR _1993_ sky130_fd_sc_hd__mux4_2
XFILLER_0_85_93 VGND VGND VPWR VPWR sky130_fd_sc_hd__decap_4
XTAP_993 VGND VPWR sky130_fd_sc_hd__tapvpwrvgnd_1
XTAP_982 VGND VPWR sky130_fd_sc_hd__tapvpwrvgnd_1
XFILLER_0_90_440 VPWR VGND VPWR VGND sky130_ef_sc_hd__decap_12
XFILLER_0_23_529 VPWR VGND VPWR VGND sky130_ef_sc_hd__decap_12
XFILLER_0_50_359 VGND VGND VPWR VPWR sky130_fd_sc_hd__decap_4
Xclkbuf_leaf_21_clock clknet_3_6__leaf_clock VGND VGND VPWR VPWR clknet_leaf_21_clock
+ sky130_fd_sc_hd__clkbuf_16
Xclkbuf_leaf_36_clock clknet_3_6__leaf_clock VGND VGND VPWR VPWR clknet_leaf_36_clock
+ sky130_fd_sc_hd__clkbuf_16
XFILLER_0_66_481 VGND VGND VPWR VPWR sky130_fd_sc_hd__fill_1
X_2750_ _1102_ _1491_ VGND VGND VPWR VPWR _1492_ sky130_fd_sc_hd__nor2_4
X_2681_ _1467_ _0961_ _0962_ fifo2.mem\[2\]\[0\] _0967_ VGND VGND VPWR VPWR _1468_
+ sky130_fd_sc_hd__o311a_1
XFILLER_0_14_518 VPWR VGND VPWR VGND sky130_ef_sc_hd__decap_12
X_4420_ clknet_leaf_2_clock _0234_ VGND VGND VPWR VPWR fifo1.mem\[6\]\[4\] sky130_fd_sc_hd__dfxtp_1
XFILLER_0_53_186 VGND VGND VPWR VPWR sky130_fd_sc_hd__decap_6
X_4351_ clknet_leaf_47_clock _0165_ VGND VGND VPWR VPWR regis.internal_parity\[6\]
+ sky130_fd_sc_hd__dfxtp_1
X_4282_ clknet_leaf_49_clock _0096_ VGND VGND VPWR VPWR fifo3.soft_reset sky130_fd_sc_hd__dfxtp_2
XTAP_201 VGND VPWR sky130_fd_sc_hd__tapvpwrvgnd_1
XTAP_212 VGND VPWR sky130_fd_sc_hd__tapvpwrvgnd_1
XTAP_223 VGND VPWR sky130_fd_sc_hd__tapvpwrvgnd_1
X_3302_ _1809_ _1928_ VGND VGND VPWR VPWR _1929_ sky130_fd_sc_hd__nor2_1
X_3233_ _1862_ VGND VGND VPWR VPWR _0516_ sky130_fd_sc_hd__clkbuf_1
XTAP_256 VGND VPWR sky130_fd_sc_hd__tapvpwrvgnd_1
XTAP_245 VGND VPWR sky130_fd_sc_hd__tapvpwrvgnd_1
XTAP_234 VGND VPWR sky130_fd_sc_hd__tapvpwrvgnd_1
XTAP_289 VGND VPWR sky130_fd_sc_hd__tapvpwrvgnd_1
XTAP_278 VGND VPWR sky130_fd_sc_hd__tapvpwrvgnd_1
XTAP_267 VGND VPWR sky130_fd_sc_hd__tapvpwrvgnd_1
X_3164_ net120 _1801_ _1803_ _0759_ VGND VGND VPWR VPWR _0506_ sky130_fd_sc_hd__a22o_1
XFILLER_0_55_52 VGND VGND VPWR VPWR sky130_fd_sc_hd__decap_4
X_2115_ _1081_ _1084_ _1085_ VGND VGND VPWR VPWR _1086_ sky130_fd_sc_hd__nand3_1
X_3095_ _0766_ _0838_ _1758_ _1768_ VGND VGND VPWR VPWR _0472_ sky130_fd_sc_hd__a31o_1
XFILLER_0_49_404 VPWR VGND VPWR VGND sky130_ef_sc_hd__decap_12
XFILLER_0_9_501 VGND VGND VPWR VPWR sky130_fd_sc_hd__decap_3
XFILLER_0_36_109 VPWR VGND VPWR VGND sky130_ef_sc_hd__decap_12
XFILLER_0_71_51 VGND VGND VPWR VPWR sky130_fd_sc_hd__decap_4
X_3997_ _0739_ VGND VGND VPWR VPWR _0934_ sky130_fd_sc_hd__buf_4
XFILLER_0_71_84 VGND VGND VPWR VPWR sky130_fd_sc_hd__fill_1
XFILLER_0_17_345 VPWR VGND VPWR VGND sky130_ef_sc_hd__decap_12
X_2948_ fifo2.mem\[7\]\[4\] _1539_ VGND VGND VPWR VPWR _1652_ sky130_fd_sc_hd__and2b_1
XFILLER_0_72_473 VGND VGND VPWR VPWR sky130_fd_sc_hd__decap_3
XFILLER_0_44_153 VPWR VGND VPWR VGND sky130_ef_sc_hd__decap_12
XFILLER_0_44_197 VPWR VGND VPWR VGND sky130_ef_sc_hd__decap_12
X_2879_ _1556_ fifo2.mem\[10\]\[2\] _1570_ VGND VGND VPWR VPWR _1585_ sky130_fd_sc_hd__o21a_1
X_4618_ clknet_leaf_32_clock _0424_ VGND VGND VPWR VPWR fifo2.wr_pointer\[2\] sky130_fd_sc_hd__dfxtp_1
X_4549_ clknet_leaf_14_clock _0355_ VGND VGND VPWR VPWR fifo1.mem\[13\]\[5\] sky130_fd_sc_hd__dfxtp_1
XTAP_790 VGND VPWR sky130_fd_sc_hd__tapvpwrvgnd_1
XFILLER_0_67_278 VGND VGND VPWR VPWR sky130_fd_sc_hd__fill_2
XFILLER_0_35_131 VGND VGND VPWR VPWR sky130_fd_sc_hd__fill_1
XFILLER_0_63_440 VGND VGND VPWR VPWR sky130_fd_sc_hd__fill_2
XFILLER_0_23_337 VGND VGND VPWR VPWR sky130_fd_sc_hd__decap_3
XFILLER_0_63_484 VGND VGND VPWR VPWR sky130_fd_sc_hd__fill_1
X_3920_ _0880_ _0882_ VGND VGND VPWR VPWR _0084_ sky130_fd_sc_hd__nor2_1
XFILLER_0_58_212 VGND VGND VPWR VPWR sky130_fd_sc_hd__fill_1
X_3851_ _0832_ _0833_ _0835_ _0693_ _0799_ VGND VGND VPWR VPWR _0836_ sky130_fd_sc_hd__o311a_1
XFILLER_0_39_470 VGND VGND VPWR VPWR sky130_fd_sc_hd__fill_2
XFILLER_0_46_429 VGND VGND VPWR VPWR sky130_fd_sc_hd__decap_6
XFILLER_0_6_515 VPWR VGND VPWR VGND sky130_ef_sc_hd__decap_12
X_3782_ _0784_ _0634_ _0770_ _0772_ VGND VGND VPWR VPWR _0785_ sky130_fd_sc_hd__nand4_4
X_2802_ _1515_ _1516_ _0874_ VGND VGND VPWR VPWR _1517_ sky130_fd_sc_hd__and3_1
XFILLER_0_54_451 VGND VGND VPWR VPWR sky130_fd_sc_hd__fill_1
X_2733_ _1108_ _1485_ _1486_ net148 VGND VGND VPWR VPWR _0392_ sky130_fd_sc_hd__a22o_1
XFILLER_0_81_281 VPWR VGND VPWR VGND sky130_ef_sc_hd__decap_12
XFILLER_0_26_197 VGND VGND VPWR VPWR sky130_fd_sc_hd__fill_1
X_2664_ _1107_ _1462_ _1463_ net277 VGND VGND VPWR VPWR _0346_ sky130_fd_sc_hd__a22o_1
X_2595_ _1425_ VGND VGND VPWR VPWR _1436_ sky130_fd_sc_hd__clkbuf_4
X_4403_ clknet_leaf_8_clock _0217_ VGND VGND VPWR VPWR fifo1.mem\[8\]\[5\] sky130_fd_sc_hd__dfxtp_1
XFILLER_0_5_21 VPWR VGND VPWR VGND sky130_ef_sc_hd__decap_12
X_4334_ clknet_leaf_46_clock _0148_ VGND VGND VPWR VPWR fifo1.data_in\[6\] sky130_fd_sc_hd__dfxtp_1
X_4265_ clknet_leaf_36_clock _0079_ VGND VGND VPWR VPWR fifo2.mem\[8\]\[8\] sky130_fd_sc_hd__dfxtp_1
X_3216_ _0008_ VGND VGND VPWR VPWR _1846_ sky130_fd_sc_hd__clkbuf_4
X_4196_ net8 _1059_ _0996_ _1068_ VGND VGND VPWR VPWR _0174_ sky130_fd_sc_hd__o211a_1
X_3147_ _1799_ VGND VGND VPWR VPWR _0493_ sky130_fd_sc_hd__clkbuf_1
X_3078_ _0831_ _0823_ VGND VGND VPWR VPWR _1759_ sky130_fd_sc_hd__nand2b_4
XFILLER_0_64_248 VGND VGND VPWR VPWR sky130_fd_sc_hd__fill_1
XFILLER_0_60_421 VGND VGND VPWR VPWR sky130_fd_sc_hd__decap_4
XFILLER_0_32_134 VGND VGND VPWR VPWR sky130_fd_sc_hd__decap_6
XFILLER_0_20_307 VGND VGND VPWR VPWR sky130_fd_sc_hd__fill_1
Xhold271 fifo2.mem\[15\]\[2\] VGND VGND VPWR VPWR net319 sky130_fd_sc_hd__dlygate4sd3_1
Xhold260 fifo2.mem\[6\]\[2\] VGND VGND VPWR VPWR net308 sky130_fd_sc_hd__dlygate4sd3_1
Xhold293 fifo3.mem\[0\]\[4\] VGND VGND VPWR VPWR net341 sky130_fd_sc_hd__dlygate4sd3_1
Xhold282 fifo2.mem\[4\]\[4\] VGND VGND VPWR VPWR net330 sky130_fd_sc_hd__dlygate4sd3_1
XFILLER_0_63_281 VPWR VGND VPWR VGND sky130_ef_sc_hd__decap_12
XFILLER_0_11_79 VGND VGND VPWR VPWR sky130_fd_sc_hd__decap_8
XFILLER_0_3_529 VPWR VGND VPWR VGND sky130_ef_sc_hd__decap_12
XFILLER_0_87_39 VPWR VGND VPWR VGND sky130_ef_sc_hd__decap_12
X_2380_ _1232_ fifo1.mem\[0\]\[4\] _1182_ VGND VGND VPWR VPWR _1266_ sky130_fd_sc_hd__o21ba_1
X_4050_ _0763_ _0960_ _0956_ _0968_ VGND VGND VPWR VPWR _0128_ sky130_fd_sc_hd__a31o_1
X_3001_ fifo2.mem\[12\]\[6\] fifo2.mem\[13\]\[6\] fifo2.mem\[14\]\[6\] fifo2.mem\[15\]\[6\]
+ _1557_ _1702_ VGND VGND VPWR VPWR _1703_ sky130_fd_sc_hd__mux4_2
Xinput6 data_in[5] VGND VGND VPWR VPWR net6 sky130_fd_sc_hd__buf_2
XFILLER_0_78_307 VGND VGND VPWR VPWR sky130_fd_sc_hd__fill_1
XFILLER_0_78_329 VPWR VGND VPWR VGND sky130_ef_sc_hd__decap_12
XFILLER_0_59_521 VGND VGND VPWR VPWR sky130_fd_sc_hd__fill_2
XFILLER_0_86_351 VPWR VGND VPWR VGND sky130_ef_sc_hd__decap_12
XFILLER_0_52_20 VGND VGND VPWR VPWR sky130_fd_sc_hd__decap_8
XFILLER_0_19_418 VGND VGND VPWR VPWR sky130_fd_sc_hd__decap_3
X_3903_ fifo2.wr_pointer\[3\] _0853_ VGND VGND VPWR VPWR _0872_ sky130_fd_sc_hd__nand2_1
X_3834_ _0820_ VGND VGND VPWR VPWR _0060_ sky130_fd_sc_hd__clkbuf_1
X_3765_ _0768_ _0755_ _0758_ net141 VGND VGND VPWR VPWR _0043_ sky130_fd_sc_hd__a22o_1
XFILLER_0_6_345 VGND VGND VPWR VPWR sky130_fd_sc_hd__decap_8
XFILLER_0_42_421 VGND VGND VPWR VPWR sky130_fd_sc_hd__fill_1
X_2716_ net97 _1481_ _1483_ _0926_ VGND VGND VPWR VPWR _0378_ sky130_fd_sc_hd__a22o_1
X_3696_ fifo2.wr_pointer\[3\] VGND VGND VPWR VPWR _0717_ sky130_fd_sc_hd__inv_2
X_2647_ _0762_ _0981_ _1446_ _1456_ VGND VGND VPWR VPWR _0336_ sky130_fd_sc_hd__a31o_1
XFILLER_0_65_3 VPWR VGND VPWR VGND sky130_ef_sc_hd__decap_12
X_2578_ _0736_ _0955_ _1433_ _1432_ net128 VGND VGND VPWR VPWR _0290_ sky130_fd_sc_hd__a32o_1
X_4317_ clknet_leaf_26_clock _0131_ VGND VGND VPWR VPWR fifo2.mem\[1\]\[8\] sky130_fd_sc_hd__dfxtp_1
XFILLER_0_77_83 VPWR VGND VPWR VGND sky130_ef_sc_hd__decap_12
X_4248_ clknet_leaf_3_clock _0062_ VGND VGND VPWR VPWR fifo3.mem\[1\]\[0\] sky130_fd_sc_hd__dfxtp_1
X_4179_ _1058_ VGND VGND VPWR VPWR _1059_ sky130_fd_sc_hd__buf_2
XTAP_1038 VGND VPWR sky130_fd_sc_hd__tapvpwrvgnd_1
XTAP_1027 VGND VPWR sky130_fd_sc_hd__tapvpwrvgnd_1
XTAP_1016 VGND VPWR sky130_fd_sc_hd__tapvpwrvgnd_1
XTAP_1005 VGND VPWR sky130_fd_sc_hd__tapvpwrvgnd_1
XTAP_1049 VGND VPWR sky130_fd_sc_hd__tapvpwrvgnd_1
XFILLER_0_65_502 VGND VGND VPWR VPWR sky130_fd_sc_hd__fill_2
XFILLER_0_45_281 VGND VGND VPWR VPWR sky130_fd_sc_hd__decap_4
XFILLER_0_33_498 VGND VGND VPWR VPWR sky130_fd_sc_hd__decap_6
XPHY_90 VGND VGND VPWR VPWR sky130_fd_sc_hd__decap_3
XFILLER_0_22_45 VPWR VGND VPWR VGND sky130_ef_sc_hd__decap_12
X_3550_ _0735_ _2105_ _2103_ _2104_ net223 VGND VGND VPWR VPWR _0590_ sky130_fd_sc_hd__a32o_1
XFILLER_0_51_240 VGND VGND VPWR VPWR sky130_fd_sc_hd__fill_2
X_2501_ _1381_ _1383_ _1175_ VGND VGND VPWR VPWR _1384_ sky130_fd_sc_hd__a21o_1
XFILLER_0_3_337 VPWR VGND VPWR VGND sky130_ef_sc_hd__decap_12
XFILLER_0_24_487 VPWR VGND VPWR VGND sky130_ef_sc_hd__decap_12
XFILLER_0_11_137 VGND VGND VPWR VPWR sky130_fd_sc_hd__decap_3
X_3481_ _0731_ _2070_ _0837_ _2074_ net67 VGND VGND VPWR VPWR _0552_ sky130_fd_sc_hd__a32o_1
X_2432_ _1189_ VGND VGND VPWR VPWR _1317_ sky130_fd_sc_hd__buf_4
X_2363_ _1232_ fifo1.mem\[12\]\[3\] _1177_ VGND VGND VPWR VPWR _1250_ sky130_fd_sc_hd__o21bai_1
X_4102_ _0693_ VGND VGND VPWR VPWR _1005_ sky130_fd_sc_hd__clkbuf_4
X_4033_ _0726_ _0727_ VGND VGND VPWR VPWR _0957_ sky130_fd_sc_hd__nand2b_4
X_2294_ _0001_ VGND VGND VPWR VPWR _1182_ sky130_fd_sc_hd__clkbuf_4
XFILLER_0_74_365 VGND VGND VPWR VPWR sky130_fd_sc_hd__fill_2
X_3817_ _0799_ _0800_ fifo3.mem\[8\]\[2\] VGND VGND VPWR VPWR _0809_ sky130_fd_sc_hd__and3_1
X_4797_ clknet_leaf_49_clock _0603_ VGND VGND VPWR VPWR fifo3.mem\[13\]\[7\] sky130_fd_sc_hd__dfxtp_1
XFILLER_0_27_281 VGND VGND VPWR VPWR sky130_fd_sc_hd__fill_2
XFILLER_0_6_175 VGND VGND VPWR VPWR sky130_fd_sc_hd__decap_8
X_3748_ _0731_ VGND VGND VPWR VPWR _0759_ sky130_fd_sc_hd__clkbuf_8
XFILLER_0_15_487 VGND VGND VPWR VPWR sky130_fd_sc_hd__fill_1
XFILLER_0_15_465 VGND VGND VPWR VPWR sky130_fd_sc_hd__fill_2
XFILLER_0_6_197 VPWR VGND VPWR VGND sky130_ef_sc_hd__decap_12
XFILLER_0_30_402 VGND VGND VPWR VPWR sky130_fd_sc_hd__fill_1
X_3679_ _0702_ _0703_ _0701_ VGND VGND VPWR VPWR _0022_ sky130_fd_sc_hd__nor3_1
XFILLER_0_38_513 VPWR VGND VPWR VGND sky130_ef_sc_hd__decap_12
XFILLER_0_77_181 VGND VGND VPWR VPWR sky130_fd_sc_hd__decap_8
XFILLER_0_53_505 VGND VGND VPWR VPWR sky130_fd_sc_hd__decap_6
XFILLER_0_53_538 VGND VGND VPWR VPWR sky130_fd_sc_hd__decap_3
XFILLER_0_21_457 VGND VGND VPWR VPWR sky130_fd_sc_hd__decap_4
XTAP_608 VGND VPWR sky130_fd_sc_hd__tapvpwrvgnd_1
XTAP_619 VGND VPWR sky130_fd_sc_hd__tapvpwrvgnd_1
XFILLER_0_88_457 VGND VGND VPWR VPWR sky130_fd_sc_hd__decap_3
XFILLER_0_75_129 VGND VGND VPWR VPWR sky130_fd_sc_hd__fill_2
XFILLER_0_33_77 VGND VGND VPWR VPWR sky130_fd_sc_hd__fill_1
X_2981_ _1683_ _1542_ _1538_ VGND VGND VPWR VPWR _1684_ sky130_fd_sc_hd__a21oi_1
XFILLER_0_68_170 VGND VGND VPWR VPWR sky130_fd_sc_hd__fill_1
XFILLER_0_8_429 VGND VGND VPWR VPWR sky130_fd_sc_hd__fill_1
X_4720_ clknet_leaf_50_clock _0526_ VGND VGND VPWR VPWR fifo3.wr_pointer\[4\] sky130_fd_sc_hd__dfxtp_1
X_4651_ clknet_leaf_48_clock _0457_ VGND VGND VPWR VPWR fifo3.mem\[14\]\[1\] sky130_fd_sc_hd__dfxtp_1
XFILLER_0_71_335 VGND VGND VPWR VPWR sky130_fd_sc_hd__fill_1
X_3602_ _0635_ _0636_ _0638_ _0639_ VGND VGND VPWR VPWR _0640_ sky130_fd_sc_hd__and4_1
XFILLER_0_24_251 VGND VGND VPWR VPWR sky130_fd_sc_hd__fill_1
X_4582_ clknet_leaf_9_clock _0388_ VGND VGND VPWR VPWR fifo1.mem\[11\]\[2\] sky130_fd_sc_hd__dfxtp_1
X_3533_ _0833_ _1417_ _1773_ _0693_ _0799_ VGND VGND VPWR VPWR _2098_ sky130_fd_sc_hd__o311a_1
XFILLER_0_12_468 VGND VGND VPWR VPWR sky130_fd_sc_hd__decap_8
X_3464_ fifo3.count\[5\] _2039_ _0790_ VGND VGND VPWR VPWR _2065_ sky130_fd_sc_hd__o21ai_1
XFILLER_0_58_74 VGND VGND VPWR VPWR sky130_fd_sc_hd__fill_1
X_2415_ _1296_ fifo1.mem\[6\]\[5\] _1178_ VGND VGND VPWR VPWR _1300_ sky130_fd_sc_hd__o21ai_1
X_3395_ _2004_ VGND VGND VPWR VPWR _0536_ sky130_fd_sc_hd__buf_1
X_2346_ _0001_ VGND VGND VPWR VPWR _1233_ sky130_fd_sc_hd__clkbuf_4
X_2277_ fifo1.rd_pointer\[3\] fifo1.rd_pointer\[2\] VGND VGND VPWR VPWR _1167_ sky130_fd_sc_hd__and2_1
XFILLER_0_74_62 VGND VGND VPWR VPWR sky130_fd_sc_hd__fill_2
X_4016_ fifo3.mem\[6\]\[2\] _0944_ _0942_ VGND VGND VPWR VPWR _0947_ sky130_fd_sc_hd__a21bo_1
XFILLER_0_28_3 VPWR VGND VPWR VGND sky130_ef_sc_hd__decap_12
XFILLER_0_90_83 VGND VGND VPWR VPWR sky130_fd_sc_hd__fill_1
XFILLER_0_35_505 VPWR VGND VPWR VGND sky130_ef_sc_hd__decap_12
XFILLER_0_30_243 VGND VGND VPWR VPWR sky130_fd_sc_hd__fill_2
XFILLER_0_30_276 VGND VGND VPWR VPWR sky130_fd_sc_hd__decap_8
XFILLER_0_85_405 VGND VGND VPWR VPWR sky130_fd_sc_hd__decap_4
XFILLER_0_85_449 VPWR VGND VPWR VGND sky130_ef_sc_hd__decap_12
XFILLER_0_38_365 VGND VGND VPWR VPWR sky130_fd_sc_hd__decap_3
XFILLER_0_38_376 VGND VGND VPWR VPWR sky130_fd_sc_hd__fill_2
XFILLER_0_80_121 VGND VGND VPWR VPWR sky130_fd_sc_hd__fill_1
XFILLER_0_0_159 VGND VGND VPWR VPWR sky130_fd_sc_hd__decap_8
XFILLER_0_0_137 VGND VGND VPWR VPWR sky130_fd_sc_hd__decap_3
XTAP_405 VGND VPWR sky130_fd_sc_hd__tapvpwrvgnd_1
XTAP_416 VGND VPWR sky130_fd_sc_hd__tapvpwrvgnd_1
XTAP_427 VGND VPWR sky130_fd_sc_hd__tapvpwrvgnd_1
XTAP_438 VGND VPWR sky130_fd_sc_hd__tapvpwrvgnd_1
XTAP_449 VGND VPWR sky130_fd_sc_hd__tapvpwrvgnd_1
X_2200_ _1124_ VGND VGND VPWR VPWR _1125_ sky130_fd_sc_hd__clkbuf_4
X_3180_ _1811_ VGND VGND VPWR VPWR _1812_ sky130_fd_sc_hd__buf_4
X_2131_ net299 _1091_ _1093_ _0938_ VGND VGND VPWR VPWR _0183_ sky130_fd_sc_hd__a22o_1
XFILLER_0_88_221 VPWR VGND VPWR VGND sky130_ef_sc_hd__decap_12
XFILLER_0_88_265 VGND VGND VPWR VPWR sky130_fd_sc_hd__fill_2
XFILLER_0_48_107 VGND VGND VPWR VPWR sky130_fd_sc_hd__fill_1
XFILLER_0_17_505 VPWR VGND VPWR VGND sky130_ef_sc_hd__decap_12
X_2964_ _1665_ _1557_ _1666_ VGND VGND VPWR VPWR _1667_ sky130_fd_sc_hd__a21oi_1
X_4703_ clknet_leaf_7_clock _0509_ VGND VGND VPWR VPWR fifo1.mem\[14\]\[4\] sky130_fd_sc_hd__dfxtp_1
X_2895_ _1556_ fifo2.mem\[0\]\[3\] _0005_ VGND VGND VPWR VPWR _1600_ sky130_fd_sc_hd__o21ba_1
XFILLER_0_71_121 VGND VGND VPWR VPWR sky130_fd_sc_hd__fill_1
X_4634_ clknet_leaf_30_clock _0440_ VGND VGND VPWR VPWR fifo2.count\[0\] sky130_fd_sc_hd__dfxtp_1
XFILLER_0_4_421 VGND VGND VPWR VPWR sky130_fd_sc_hd__decap_4
XFILLER_0_4_432 VPWR VGND VPWR VGND sky130_ef_sc_hd__decap_12
XFILLER_0_8_65 VPWR VGND VPWR VGND sky130_ef_sc_hd__decap_12
XFILLER_0_4_465 VGND VGND VPWR VPWR sky130_fd_sc_hd__decap_8
X_4565_ clknet_leaf_21_clock _0371_ VGND VGND VPWR VPWR fifo2.mem\[5\]\[3\] sky130_fd_sc_hd__dfxtp_1
X_3516_ _1760_ _1779_ _1781_ fifo3.mem\[10\]\[4\] _1783_ VGND VGND VPWR VPWR _2089_
+ sky130_fd_sc_hd__o311a_1
XFILLER_0_69_84 VGND VGND VPWR VPWR sky130_fd_sc_hd__decap_3
X_4496_ clknet_leaf_38_clock _0302_ VGND VGND VPWR VPWR fifo2.mem\[12\]\[6\] sky130_fd_sc_hd__dfxtp_1
Xclkbuf_leaf_2_clock clknet_3_0__leaf_clock VGND VGND VPWR VPWR clknet_leaf_2_clock
+ sky130_fd_sc_hd__clkbuf_16
X_3447_ fifo3.count\[4\] fifo3.count\[3\] _2036_ VGND VGND VPWR VPWR _2049_ sky130_fd_sc_hd__or3_1
XTAP_961 VGND VPWR sky130_fd_sc_hd__tapvpwrvgnd_1
XTAP_950 VGND VPWR sky130_fd_sc_hd__tapvpwrvgnd_1
X_3378_ fifo2.mem\[8\]\[0\] fifo2.mem\[9\]\[0\] fifo2.mem\[10\]\[0\] fifo2.mem\[11\]\[0\]
+ _1669_ _1702_ VGND VGND VPWR VPWR _1992_ sky130_fd_sc_hd__mux4_1
XTAP_994 VGND VPWR sky130_fd_sc_hd__tapvpwrvgnd_1
XTAP_983 VGND VPWR sky130_fd_sc_hd__tapvpwrvgnd_1
XTAP_972 VGND VPWR sky130_fd_sc_hd__tapvpwrvgnd_1
X_2329_ _1203_ fifo1.mem\[13\]\[2\] _1216_ VGND VGND VPWR VPWR _1217_ sky130_fd_sc_hd__o21ai_1
XFILLER_0_79_243 VGND VGND VPWR VPWR sky130_fd_sc_hd__decap_8
XFILLER_0_67_449 VGND VGND VPWR VPWR sky130_fd_sc_hd__fill_2
XFILLER_0_35_357 VGND VGND VPWR VPWR sky130_fd_sc_hd__fill_2
XFILLER_0_62_121 VGND VGND VPWR VPWR sky130_fd_sc_hd__fill_1
XFILLER_0_90_452 VPWR VGND VPWR VGND sky130_ef_sc_hd__decap_12
XFILLER_0_85_279 VGND VGND VPWR VPWR sky130_fd_sc_hd__fill_1
XFILLER_0_53_121 VGND VGND VPWR VPWR sky130_fd_sc_hd__decap_3
XFILLER_0_41_316 VGND VGND VPWR VPWR sky130_fd_sc_hd__fill_1
X_2680_ _0727_ _0726_ VGND VGND VPWR VPWR _1467_ sky130_fd_sc_hd__nand2b_4
X_4350_ clknet_leaf_43_clock _0164_ VGND VGND VPWR VPWR regis.internal_parity\[5\]
+ sky130_fd_sc_hd__dfxtp_1
X_3301_ _1924_ _1925_ _1926_ _1927_ VGND VGND VPWR VPWR _1928_ sky130_fd_sc_hd__o22a_1
X_4281_ clknet_leaf_47_clock _0095_ VGND VGND VPWR VPWR syn.count2\[5\] sky130_fd_sc_hd__dfxtp_1
XTAP_202 VGND VPWR sky130_fd_sc_hd__tapvpwrvgnd_1
XTAP_213 VGND VPWR sky130_fd_sc_hd__tapvpwrvgnd_1
XTAP_224 VGND VPWR sky130_fd_sc_hd__tapvpwrvgnd_1
XTAP_257 VGND VPWR sky130_fd_sc_hd__tapvpwrvgnd_1
XTAP_246 VGND VPWR sky130_fd_sc_hd__tapvpwrvgnd_1
XTAP_235 VGND VPWR sky130_fd_sc_hd__tapvpwrvgnd_1
X_3232_ _1845_ _1861_ _0874_ VGND VGND VPWR VPWR _1862_ sky130_fd_sc_hd__and3_1
X_3163_ net124 _1801_ _1803_ _0747_ VGND VGND VPWR VPWR _0505_ sky130_fd_sc_hd__a22o_1
XTAP_279 VGND VPWR sky130_fd_sc_hd__tapvpwrvgnd_1
XTAP_268 VGND VPWR sky130_fd_sc_hd__tapvpwrvgnd_1
X_2114_ _1078_ regis.internal_parity\[1\] _1083_ regis.packet_parity\[2\] VGND VGND
+ VPWR VPWR _1085_ sky130_fd_sc_hd__a22oi_1
X_3094_ _1759_ _1419_ _0835_ _0782_ fifo3.mem\[2\]\[7\] VGND VGND VPWR VPWR _1768_
+ sky130_fd_sc_hd__o311a_1
XFILLER_0_55_86 VGND VGND VPWR VPWR sky130_fd_sc_hd__fill_2
XFILLER_0_49_416 VGND VGND VPWR VPWR sky130_fd_sc_hd__decap_8
XFILLER_0_17_313 VGND VGND VPWR VPWR sky130_fd_sc_hd__decap_3
X_3996_ _0932_ _0924_ _0933_ VGND VGND VPWR VPWR _0109_ sky130_fd_sc_hd__a21o_1
X_2947_ _1569_ fifo2.mem\[6\]\[4\] _1562_ VGND VGND VPWR VPWR _1651_ sky130_fd_sc_hd__o21ai_1
XFILLER_0_17_379 VGND VGND VPWR VPWR sky130_fd_sc_hd__decap_8
XFILLER_0_17_357 VGND VGND VPWR VPWR sky130_fd_sc_hd__decap_4
XFILLER_0_44_165 VPWR VGND VPWR VGND sky130_ef_sc_hd__decap_12
X_2878_ _1582_ fifo2.mem\[9\]\[2\] _1583_ VGND VGND VPWR VPWR _1584_ sky130_fd_sc_hd__o21ai_1
X_4617_ clknet_leaf_34_clock _0423_ VGND VGND VPWR VPWR fifo2.wr_pointer\[1\] sky130_fd_sc_hd__dfxtp_1
X_4548_ clknet_leaf_11_clock _0354_ VGND VGND VPWR VPWR fifo1.mem\[13\]\[4\] sky130_fd_sc_hd__dfxtp_1
X_4479_ clknet_leaf_37_clock _0285_ VGND VGND VPWR VPWR fifo2.mem\[14\]\[7\] sky130_fd_sc_hd__dfxtp_1
XTAP_780 VGND VPWR sky130_fd_sc_hd__tapvpwrvgnd_1
XTAP_791 VGND VPWR sky130_fd_sc_hd__tapvpwrvgnd_1
XFILLER_0_35_110 VGND VGND VPWR VPWR sky130_fd_sc_hd__fill_2
XFILLER_0_50_157 VGND VGND VPWR VPWR sky130_fd_sc_hd__decap_6
XFILLER_0_50_179 VGND VGND VPWR VPWR sky130_fd_sc_hd__decap_3
XFILLER_0_31_393 VGND VGND VPWR VPWR sky130_fd_sc_hd__decap_8
XFILLER_0_86_533 VGND VGND VPWR VPWR sky130_fd_sc_hd__decap_8
X_3850_ _0834_ VGND VGND VPWR VPWR _0835_ sky130_fd_sc_hd__clkbuf_4
XFILLER_0_46_419 VGND VGND VPWR VPWR sky130_fd_sc_hd__fill_1
XFILLER_0_6_527 VGND VGND VPWR VPWR sky130_fd_sc_hd__decap_4
X_3781_ _0633_ _0773_ _0774_ _0775_ VGND VGND VPWR VPWR _0784_ sky130_fd_sc_hd__o31a_4
XFILLER_0_41_55 VGND VGND VPWR VPWR sky130_fd_sc_hd__fill_1
X_2801_ fifo2.rd_pointer\[4\] fifo2.rd_pointer\[3\] fifo2.rd_pointer\[2\] net43 VGND
+ VGND VPWR VPWR _1516_ sky130_fd_sc_hd__nand4_1
X_2732_ _1107_ _1485_ _1486_ net285 VGND VGND VPWR VPWR _0391_ sky130_fd_sc_hd__a22o_1
XFILLER_0_81_293 VGND VGND VPWR VPWR sky130_fd_sc_hd__decap_4
XFILLER_0_41_113 VGND VGND VPWR VPWR sky130_fd_sc_hd__decap_4
X_2663_ _1106_ _1462_ _1463_ net95 VGND VGND VPWR VPWR _0345_ sky130_fd_sc_hd__a22o_1
XFILLER_0_22_360 VGND VGND VPWR VPWR sky130_fd_sc_hd__decap_4
X_2594_ _0854_ _1425_ VGND VGND VPWR VPWR _1435_ sky130_fd_sc_hd__nand2_4
X_4402_ clknet_leaf_10_clock _0216_ VGND VGND VPWR VPWR fifo1.mem\[8\]\[4\] sky130_fd_sc_hd__dfxtp_1
XFILLER_0_10_533 VGND VGND VPWR VPWR sky130_fd_sc_hd__decap_8
X_4333_ clknet_leaf_42_clock _0147_ VGND VGND VPWR VPWR fifo1.data_in\[5\] sky130_fd_sc_hd__dfxtp_1
XFILLER_0_5_33 VPWR VGND VPWR VGND sky130_ef_sc_hd__decap_12
X_4264_ clknet_leaf_38_clock _0078_ VGND VGND VPWR VPWR fifo2.mem\[8\]\[7\] sky130_fd_sc_hd__dfxtp_1
X_3215_ _1827_ _1837_ _0011_ _1844_ VGND VGND VPWR VPWR _1845_ sky130_fd_sc_hd__o211ai_4
XFILLER_0_66_41 VPWR VGND VPWR VGND sky130_ef_sc_hd__decap_12
X_4195_ regis.packet_parity\[7\] _0682_ VGND VGND VPWR VPWR _1068_ sky130_fd_sc_hd__or2_1
XFILLER_0_66_85 VGND VGND VPWR VPWR sky130_fd_sc_hd__fill_1
X_3146_ net44 _1510_ _0694_ VGND VGND VPWR VPWR _1799_ sky130_fd_sc_hd__and3b_1
X_3077_ _0941_ VGND VGND VPWR VPWR _1758_ sky130_fd_sc_hd__clkbuf_4
XFILLER_0_89_393 VGND VGND VPWR VPWR sky130_fd_sc_hd__decap_8
XFILLER_0_82_73 VGND VGND VPWR VPWR sky130_fd_sc_hd__decap_3
XFILLER_0_77_511 VGND VGND VPWR VPWR sky130_fd_sc_hd__fill_1
XFILLER_0_10_3 VPWR VGND VPWR VGND sky130_ef_sc_hd__decap_12
XFILLER_0_9_321 VPWR VGND VPWR VGND sky130_ef_sc_hd__decap_12
XFILLER_0_49_268 VPWR VGND VPWR VGND sky130_ef_sc_hd__decap_12
Xclkbuf_leaf_20_clock clknet_3_3__leaf_clock VGND VGND VPWR VPWR clknet_leaf_20_clock
+ sky130_fd_sc_hd__clkbuf_16
XFILLER_0_9_354 VGND VGND VPWR VPWR sky130_fd_sc_hd__fill_2
X_3979_ _0826_ VGND VGND VPWR VPWR _0921_ sky130_fd_sc_hd__buf_4
XFILLER_0_72_282 VGND VGND VPWR VPWR sky130_fd_sc_hd__decap_8
Xclkbuf_leaf_35_clock clknet_3_6__leaf_clock VGND VGND VPWR VPWR clknet_leaf_35_clock
+ sky130_fd_sc_hd__clkbuf_16
XFILLER_0_60_455 VPWR VGND VPWR VGND sky130_ef_sc_hd__decap_12
XFILLER_0_13_371 VPWR VGND VPWR VGND sky130_ef_sc_hd__decap_12
XFILLER_0_60_499 VGND VGND VPWR VPWR sky130_fd_sc_hd__fill_1
Xhold261 syn.count1\[0\] VGND VGND VPWR VPWR net309 sky130_fd_sc_hd__dlygate4sd3_1
Xhold250 fifo1.mem\[6\]\[7\] VGND VGND VPWR VPWR net298 sky130_fd_sc_hd__dlygate4sd3_1
Xhold283 fifo2.mem\[8\]\[1\] VGND VGND VPWR VPWR net331 sky130_fd_sc_hd__dlygate4sd3_1
Xhold272 fifo2.mem\[15\]\[5\] VGND VGND VPWR VPWR net320 sky130_fd_sc_hd__dlygate4sd3_1
Xhold294 fifo2.mem\[0\]\[4\] VGND VGND VPWR VPWR net342 sky130_fd_sc_hd__dlygate4sd3_1
XFILLER_0_68_533 VGND VGND VPWR VPWR sky130_fd_sc_hd__decap_8
XFILLER_0_83_503 VGND VGND VPWR VPWR sky130_fd_sc_hd__fill_1
XFILLER_0_36_474 VGND VGND VPWR VPWR sky130_fd_sc_hd__fill_2
XFILLER_0_51_411 VGND VGND VPWR VPWR sky130_fd_sc_hd__decap_8
XFILLER_0_63_260 VPWR VGND VPWR VGND sky130_ef_sc_hd__decap_12
XFILLER_0_23_124 VGND VGND VPWR VPWR sky130_fd_sc_hd__fill_1
XFILLER_0_23_135 VGND VGND VPWR VPWR sky130_fd_sc_hd__decap_6
XFILLER_0_23_146 VGND VGND VPWR VPWR sky130_fd_sc_hd__decap_8
XFILLER_0_63_293 VGND VGND VPWR VPWR sky130_fd_sc_hd__decap_3
XFILLER_0_51_477 VGND VGND VPWR VPWR sky130_fd_sc_hd__fill_1
Xinput7 data_in[6] VGND VGND VPWR VPWR net7 sky130_fd_sc_hd__buf_2
XFILLER_0_36_55 VGND VGND VPWR VPWR sky130_fd_sc_hd__decap_4
X_3000_ _1562_ VGND VGND VPWR VPWR _1702_ sky130_fd_sc_hd__buf_4
XFILLER_0_86_363 VGND VGND VPWR VPWR sky130_fd_sc_hd__fill_1
XFILLER_0_19_408 VGND VGND VPWR VPWR sky130_fd_sc_hd__fill_1
X_3902_ _0870_ VGND VGND VPWR VPWR _0871_ sky130_fd_sc_hd__clkbuf_4
XFILLER_0_52_43 VGND VGND VPWR VPWR sky130_fd_sc_hd__decap_6
X_3833_ _0819_ _0765_ _0805_ VGND VGND VPWR VPWR _0820_ sky130_fd_sc_hd__mux2_1
XFILLER_0_61_208 VGND VGND VPWR VPWR sky130_fd_sc_hd__decap_6
XFILLER_0_27_496 VGND VGND VPWR VPWR sky130_fd_sc_hd__decap_8
X_3764_ _0767_ VGND VGND VPWR VPWR _0768_ sky130_fd_sc_hd__buf_4
X_2715_ net77 _1481_ _1483_ _0925_ VGND VGND VPWR VPWR _0377_ sky130_fd_sc_hd__a22o_1
X_3695_ _0619_ VGND VGND VPWR VPWR _0716_ sky130_fd_sc_hd__buf_2
X_2646_ _1447_ _1448_ _1450_ _1451_ fifo2.mem\[7\]\[4\] VGND VGND VPWR VPWR _1456_
+ sky130_fd_sc_hd__o311a_1
X_2577_ _0734_ _0955_ _1433_ _1432_ net200 VGND VGND VPWR VPWR _0289_ sky130_fd_sc_hd__a32o_1
XFILLER_0_58_3 VGND VGND VPWR VPWR sky130_fd_sc_hd__decap_6
X_4316_ clknet_leaf_26_clock _0130_ VGND VGND VPWR VPWR fifo2.mem\[1\]\[7\] sky130_fd_sc_hd__dfxtp_1
XFILLER_0_77_95 VGND VGND VPWR VPWR sky130_fd_sc_hd__decap_8
XFILLER_0_10_396 VGND VGND VPWR VPWR sky130_fd_sc_hd__decap_3
X_4247_ clknet_leaf_58_clock _0061_ VGND VGND VPWR VPWR fifo3.mem\[8\]\[8\] sky130_fd_sc_hd__dfxtp_1
X_4178_ _0660_ _0681_ VGND VGND VPWR VPWR _1058_ sky130_fd_sc_hd__or2b_1
X_3129_ fifo3.mem\[4\]\[1\] _0842_ _1788_ VGND VGND VPWR VPWR _1791_ sky130_fd_sc_hd__a21bo_1
XTAP_1028 VGND VPWR sky130_fd_sc_hd__tapvpwrvgnd_1
XTAP_1017 VGND VPWR sky130_fd_sc_hd__tapvpwrvgnd_1
XTAP_1006 VGND VPWR sky130_fd_sc_hd__tapvpwrvgnd_1
XTAP_1039 VGND VPWR sky130_fd_sc_hd__tapvpwrvgnd_1
XFILLER_0_65_525 VPWR VGND VPWR VGND sky130_ef_sc_hd__decap_12
XFILLER_0_20_149 VGND VGND VPWR VPWR sky130_fd_sc_hd__decap_3
XPHY_80 VGND VGND VPWR VPWR sky130_fd_sc_hd__decap_3
XPHY_91 VGND VGND VPWR VPWR sky130_fd_sc_hd__decap_3
XFILLER_0_22_57 VGND VGND VPWR VPWR sky130_fd_sc_hd__fill_1
X_2500_ fifo1.mem\[15\]\[7\] _1320_ _1382_ VGND VGND VPWR VPWR _1383_ sky130_fd_sc_hd__o21ai_1
XFILLER_0_3_349 VPWR VGND VPWR VGND sky130_ef_sc_hd__decap_12
XFILLER_0_24_477 VGND VGND VPWR VPWR sky130_fd_sc_hd__fill_1
X_3480_ _0833_ _0823_ _0831_ _0834_ _0789_ VGND VGND VPWR VPWR _2074_ sky130_fd_sc_hd__o41a_1
XFILLER_0_24_499 VPWR VGND VPWR VGND sky130_ef_sc_hd__decap_12
X_2431_ fifo1.mem\[9\]\[5\] VGND VGND VPWR VPWR _1316_ sky130_fd_sc_hd__inv_2
XFILLER_0_51_285 VGND VGND VPWR VPWR sky130_fd_sc_hd__fill_1
X_2362_ _1246_ _1248_ _0002_ VGND VGND VPWR VPWR _1249_ sky130_fd_sc_hd__a21o_1
X_2293_ _0003_ VGND VGND VPWR VPWR _1181_ sky130_fd_sc_hd__clkbuf_4
X_4101_ regis.header_byte\[2\] _0684_ _1003_ _0988_ VGND VGND VPWR VPWR _1004_ sky130_fd_sc_hd__o2bb2a_1
XFILLER_0_47_54 VGND VGND VPWR VPWR sky130_fd_sc_hd__fill_2
X_4032_ _0955_ VGND VGND VPWR VPWR _0956_ sky130_fd_sc_hd__clkbuf_4
XFILLER_0_59_341 VGND VGND VPWR VPWR sky130_fd_sc_hd__decap_4
XFILLER_0_59_352 VGND VGND VPWR VPWR sky130_fd_sc_hd__decap_4
XFILLER_0_47_525 VPWR VGND VPWR VGND sky130_ef_sc_hd__decap_12
XFILLER_0_74_399 VGND VGND VPWR VPWR sky130_fd_sc_hd__decap_6
X_4796_ clknet_leaf_55_clock _0602_ VGND VGND VPWR VPWR fifo3.mem\[13\]\[6\] sky130_fd_sc_hd__dfxtp_1
X_3816_ _0808_ VGND VGND VPWR VPWR _0054_ sky130_fd_sc_hd__clkbuf_1
XFILLER_0_27_271 VGND VGND VPWR VPWR sky130_fd_sc_hd__decap_8
X_3747_ _0747_ _0755_ _0758_ net87 VGND VGND VPWR VPWR _0035_ sky130_fd_sc_hd__a22o_1
XFILLER_0_15_455 VGND VGND VPWR VPWR sky130_fd_sc_hd__fill_2
X_3678_ syn.count0\[0\] syn.count0\[1\] syn.count0\[2\] VGND VGND VPWR VPWR _0703_
+ sky130_fd_sc_hd__and3_1
XFILLER_0_88_83 VGND VGND VPWR VPWR sky130_fd_sc_hd__fill_1
X_2629_ net335 _0963_ _1442_ _1444_ _0744_ VGND VGND VPWR VPWR _0330_ sky130_fd_sc_hd__a32o_1
Xmax_cap47 _0971_ VGND VGND VPWR VPWR net47 sky130_fd_sc_hd__clkbuf_2
XFILLER_0_84_119 VGND VGND VPWR VPWR sky130_fd_sc_hd__decap_3
XFILLER_0_38_525 VGND VGND VPWR VPWR sky130_fd_sc_hd__decap_6
XFILLER_0_65_311 VGND VGND VPWR VPWR sky130_fd_sc_hd__fill_2
XFILLER_0_18_282 VGND VGND VPWR VPWR sky130_fd_sc_hd__decap_3
XFILLER_0_33_230 VPWR VGND VPWR VGND sky130_ef_sc_hd__decap_12
XTAP_609 VGND VPWR sky130_fd_sc_hd__tapvpwrvgnd_1
XFILLER_0_17_57 VGND VGND VPWR VPWR sky130_fd_sc_hd__fill_1
X_2980_ _1679_ _1680_ _1682_ VGND VGND VPWR VPWR _1683_ sky130_fd_sc_hd__o21ai_2
XFILLER_0_68_193 VGND VGND VPWR VPWR sky130_fd_sc_hd__decap_3
X_4650_ clknet_leaf_56_clock _0456_ VGND VGND VPWR VPWR fifo3.mem\[14\]\[0\] sky130_fd_sc_hd__dfxtp_1
Xinput10 read_enb_0 VGND VGND VPWR VPWR net10 sky130_fd_sc_hd__clkbuf_4
X_3601_ fifo3.rd_pointer\[0\] fifo3.wr_pointer\[0\] VGND VGND VPWR VPWR _0639_ sky130_fd_sc_hd__or2b_1
X_4581_ clknet_leaf_9_clock _0387_ VGND VGND VPWR VPWR fifo1.mem\[11\]\[1\] sky130_fd_sc_hd__dfxtp_1
X_3532_ _0927_ _2094_ _2097_ VGND VGND VPWR VPWR _0580_ sky130_fd_sc_hd__a21bo_1
X_3463_ net12 net42 _2062_ _2063_ _2019_ VGND VGND VPWR VPWR _2064_ sky130_fd_sc_hd__a41o_1
X_2414_ fifo1.mem\[7\]\[5\] VGND VGND VPWR VPWR _1299_ sky130_fd_sc_hd__inv_2
X_3394_ _1657_ _1658_ _1169_ VGND VGND VPWR VPWR _2004_ sky130_fd_sc_hd__and3_2
X_2345_ _0000_ VGND VGND VPWR VPWR _1232_ sky130_fd_sc_hd__buf_2
X_2276_ _1166_ VGND VGND VPWR VPWR _0255_ sky130_fd_sc_hd__clkbuf_1
X_4015_ _0926_ _0943_ _0946_ VGND VGND VPWR VPWR _0115_ sky130_fd_sc_hd__o21a_1
XFILLER_0_79_447 VGND VGND VPWR VPWR sky130_fd_sc_hd__fill_1
XFILLER_0_74_141 VPWR VGND VPWR VGND sky130_ef_sc_hd__decap_12
XFILLER_0_47_333 VGND VGND VPWR VPWR sky130_fd_sc_hd__decap_3
XFILLER_0_35_517 VPWR VGND VPWR VGND sky130_ef_sc_hd__decap_12
XFILLER_0_47_388 VGND VGND VPWR VPWR sky130_fd_sc_hd__decap_4
XFILLER_0_62_347 VPWR VGND VPWR VGND sky130_ef_sc_hd__decap_12
X_4779_ clknet_leaf_54_clock _0585_ VGND VGND VPWR VPWR fifo3.mem\[11\]\[7\] sky130_fd_sc_hd__dfxtp_1
XFILLER_0_15_274 VGND VGND VPWR VPWR sky130_fd_sc_hd__decap_6
XFILLER_0_11_480 VGND VGND VPWR VPWR sky130_fd_sc_hd__decap_8
XFILLER_0_53_325 VGND VGND VPWR VPWR sky130_fd_sc_hd__decap_3
XFILLER_0_61_391 VGND VGND VPWR VPWR sky130_fd_sc_hd__fill_1
XTAP_406 VGND VPWR sky130_fd_sc_hd__tapvpwrvgnd_1
XTAP_417 VGND VPWR sky130_fd_sc_hd__tapvpwrvgnd_1
XTAP_428 VGND VPWR sky130_fd_sc_hd__tapvpwrvgnd_1
XTAP_439 VGND VPWR sky130_fd_sc_hd__tapvpwrvgnd_1
X_2130_ net253 _1091_ _1093_ _0936_ VGND VGND VPWR VPWR _0182_ sky130_fd_sc_hd__a22o_1
XFILLER_0_88_233 VGND VGND VPWR VPWR sky130_fd_sc_hd__decap_8
XFILLER_0_44_66 VGND VGND VPWR VPWR sky130_fd_sc_hd__fill_2
XFILLER_0_29_311 VGND VGND VPWR VPWR sky130_fd_sc_hd__fill_1
XFILLER_0_69_480 VGND VGND VPWR VPWR sky130_fd_sc_hd__decap_6
XFILLER_0_56_141 VGND VGND VPWR VPWR sky130_fd_sc_hd__decap_6
X_2963_ _1550_ fifo2.mem\[4\]\[5\] _1558_ VGND VGND VPWR VPWR _1666_ sky130_fd_sc_hd__o21bai_1
XFILLER_0_84_461 VPWR VGND VPWR VGND sky130_ef_sc_hd__decap_12
XFILLER_0_17_517 VPWR VGND VPWR VGND sky130_ef_sc_hd__decap_12
X_4702_ clknet_leaf_19_clock _0508_ VGND VGND VPWR VPWR fifo1.mem\[14\]\[3\] sky130_fd_sc_hd__dfxtp_1
X_2894_ _1598_ _1542_ _0007_ VGND VGND VPWR VPWR _1599_ sky130_fd_sc_hd__a21oi_1
X_4633_ clknet_leaf_25_clock _0439_ VGND VGND VPWR VPWR net22 sky130_fd_sc_hd__dfxtp_1
XFILLER_0_32_509 VGND VGND VPWR VPWR sky130_fd_sc_hd__fill_1
XFILLER_0_4_444 VPWR VGND VPWR VGND sky130_ef_sc_hd__decap_12
X_4564_ clknet_leaf_21_clock _0370_ VGND VGND VPWR VPWR fifo2.mem\[5\]\[2\] sky130_fd_sc_hd__dfxtp_1
X_3515_ _0930_ _2084_ _2088_ VGND VGND VPWR VPWR _0572_ sky130_fd_sc_hd__a21o_1
XFILLER_0_8_77 VGND VGND VPWR VPWR sky130_fd_sc_hd__decap_6
XFILLER_0_4_477 VPWR VGND VPWR VGND sky130_ef_sc_hd__decap_12
XFILLER_0_40_531 VGND VGND VPWR VPWR sky130_fd_sc_hd__fill_1
X_4495_ clknet_leaf_36_clock _0301_ VGND VGND VPWR VPWR fifo2.mem\[12\]\[5\] sky130_fd_sc_hd__dfxtp_1
X_3446_ _2043_ _2048_ _0921_ VGND VGND VPWR VPWR _0543_ sky130_fd_sc_hd__a21oi_1
XTAP_962 VGND VPWR sky130_fd_sc_hd__tapvpwrvgnd_1
XTAP_951 VGND VPWR sky130_fd_sc_hd__tapvpwrvgnd_1
XTAP_940 VGND VPWR sky130_fd_sc_hd__tapvpwrvgnd_1
X_3377_ _1989_ _1990_ _1547_ VGND VGND VPWR VPWR _1991_ sky130_fd_sc_hd__mux2_1
XFILLER_0_40_3 VPWR VGND VPWR VGND sky130_ef_sc_hd__decap_12
XTAP_995 VGND VPWR sky130_fd_sc_hd__tapvpwrvgnd_1
XTAP_984 VGND VPWR sky130_fd_sc_hd__tapvpwrvgnd_1
XTAP_973 VGND VPWR sky130_fd_sc_hd__tapvpwrvgnd_1
X_2328_ _1188_ fifo1.mem\[12\]\[2\] _0001_ VGND VGND VPWR VPWR _1216_ sky130_fd_sc_hd__o21ba_1
XFILLER_0_79_222 VGND VGND VPWR VPWR sky130_fd_sc_hd__fill_2
X_2259_ _1143_ _1150_ _0756_ VGND VGND VPWR VPWR _1153_ sky130_fd_sc_hd__a21oi_4
XFILLER_0_90_464 VPWR VGND VPWR VGND sky130_ef_sc_hd__decap_12
XFILLER_0_85_225 VPWR VGND VPWR VGND sky130_ef_sc_hd__decap_12
XFILLER_0_38_141 VGND VGND VPWR VPWR sky130_fd_sc_hd__decap_4
XFILLER_0_38_152 VPWR VGND VPWR VGND sky130_ef_sc_hd__decap_12
XFILLER_0_81_442 VGND VGND VPWR VPWR sky130_fd_sc_hd__decap_6
XFILLER_0_5_219 VGND VGND VPWR VPWR sky130_fd_sc_hd__decap_4
XFILLER_0_26_358 VGND VGND VPWR VPWR sky130_fd_sc_hd__decap_3
XFILLER_0_1_447 VGND VGND VPWR VPWR sky130_fd_sc_hd__fill_1
X_3300_ fifo3.mem\[1\]\[5\] _1804_ VGND VGND VPWR VPWR _1927_ sky130_fd_sc_hd__and2b_1
X_4280_ clknet_leaf_47_clock _0094_ VGND VGND VPWR VPWR syn.count2\[4\] sky130_fd_sc_hd__dfxtp_1
XTAP_203 VGND VPWR sky130_fd_sc_hd__tapvpwrvgnd_1
XTAP_214 VGND VPWR sky130_fd_sc_hd__tapvpwrvgnd_1
XFILLER_0_39_66 VGND VGND VPWR VPWR sky130_fd_sc_hd__decap_8
XTAP_247 VGND VPWR sky130_fd_sc_hd__tapvpwrvgnd_1
XTAP_225 VGND VPWR sky130_fd_sc_hd__tapvpwrvgnd_1
XTAP_236 VGND VPWR sky130_fd_sc_hd__tapvpwrvgnd_1
X_3231_ _1827_ _1852_ _1860_ _1816_ VGND VGND VPWR VPWR _1861_ sky130_fd_sc_hd__o211ai_4
XTAP_269 VGND VPWR sky130_fd_sc_hd__tapvpwrvgnd_1
XTAP_258 VGND VPWR sky130_fd_sc_hd__tapvpwrvgnd_1
X_3162_ _1802_ VGND VGND VPWR VPWR _1803_ sky130_fd_sc_hd__clkbuf_4
X_2113_ regis.packet_parity\[4\] _1082_ _1083_ regis.packet_parity\[2\] VGND VGND
+ VPWR VPWR _1084_ sky130_fd_sc_hd__o22a_1
X_3093_ _0764_ _0838_ _1758_ _1767_ VGND VGND VPWR VPWR _0471_ sky130_fd_sc_hd__a31o_1
XFILLER_0_55_65 VGND VGND VPWR VPWR sky130_fd_sc_hd__decap_4
XFILLER_0_64_409 VGND VGND VPWR VPWR sky130_fd_sc_hd__decap_8
XFILLER_0_76_269 VGND VGND VPWR VPWR sky130_fd_sc_hd__decap_8
X_3995_ _0928_ _0786_ fifo3.mem\[5\]\[4\] VGND VGND VPWR VPWR _0933_ sky130_fd_sc_hd__and3_1
XFILLER_0_57_461 VGND VGND VPWR VPWR sky130_fd_sc_hd__decap_8
X_2946_ fifo2.mem\[5\]\[4\] _1556_ VGND VGND VPWR VPWR _1650_ sky130_fd_sc_hd__and2b_1
X_2877_ _1567_ fifo2.mem\[8\]\[2\] _1558_ VGND VGND VPWR VPWR _1583_ sky130_fd_sc_hd__o21ba_1
XFILLER_0_88_3 VPWR VGND VPWR VGND sky130_ef_sc_hd__decap_12
XFILLER_0_44_177 VPWR VGND VPWR VGND sky130_ef_sc_hd__decap_12
X_4616_ clknet_leaf_35_clock _0422_ VGND VGND VPWR VPWR fifo2.wr_pointer\[0\] sky130_fd_sc_hd__dfxtp_2
X_4547_ clknet_leaf_15_clock _0353_ VGND VGND VPWR VPWR fifo1.mem\[13\]\[3\] sky130_fd_sc_hd__dfxtp_1
X_4478_ clknet_leaf_51_clock _0284_ VGND VGND VPWR VPWR fifo2.mem\[14\]\[6\] sky130_fd_sc_hd__dfxtp_1
X_3429_ _1904_ _1915_ VGND VGND VPWR VPWR _2033_ sky130_fd_sc_hd__nand2_1
XTAP_770 VGND VPWR sky130_fd_sc_hd__tapvpwrvgnd_1
XTAP_781 VGND VPWR sky130_fd_sc_hd__tapvpwrvgnd_1
XTAP_792 VGND VPWR sky130_fd_sc_hd__tapvpwrvgnd_1
XFILLER_0_86_501 VPWR VGND VPWR VGND sky130_ef_sc_hd__decap_12
XFILLER_0_58_203 VGND VGND VPWR VPWR sky130_fd_sc_hd__fill_1
Xclkbuf_leaf_1_clock clknet_3_0__leaf_clock VGND VGND VPWR VPWR clknet_leaf_1_clock
+ sky130_fd_sc_hd__clkbuf_16
XFILLER_0_26_122 VGND VGND VPWR VPWR sky130_fd_sc_hd__decap_3
X_3780_ _0782_ VGND VGND VPWR VPWR _0783_ sky130_fd_sc_hd__clkbuf_4
X_2800_ fifo2.rd_pointer\[3\] fifo2.rd_pointer\[2\] net43 fifo2.rd_pointer\[4\] VGND
+ VGND VPWR VPWR _1515_ sky130_fd_sc_hd__a31o_1
XFILLER_0_54_431 VGND VGND VPWR VPWR sky130_fd_sc_hd__decap_3
X_2731_ _1106_ _1485_ _1486_ net162 VGND VGND VPWR VPWR _0390_ sky130_fd_sc_hd__a22o_1
XFILLER_0_14_317 VGND VGND VPWR VPWR sky130_fd_sc_hd__fill_1
X_4401_ clknet_leaf_9_clock _0215_ VGND VGND VPWR VPWR fifo1.mem\[8\]\[3\] sky130_fd_sc_hd__dfxtp_1
X_2662_ _1105_ _1462_ _1463_ net214 VGND VGND VPWR VPWR _0344_ sky130_fd_sc_hd__a22o_1
X_2593_ _0745_ _0851_ _1428_ _1434_ net220 VGND VGND VPWR VPWR _0304_ sky130_fd_sc_hd__a32o_1
X_4332_ clknet_leaf_43_clock _0146_ VGND VGND VPWR VPWR fifo1.data_in\[4\] sky130_fd_sc_hd__dfxtp_1
XFILLER_0_5_45 VGND VGND VPWR VPWR sky130_fd_sc_hd__decap_8
X_4263_ clknet_leaf_41_clock _0077_ VGND VGND VPWR VPWR fifo2.mem\[8\]\[6\] sky130_fd_sc_hd__dfxtp_1
X_3214_ _1840_ _1843_ _1812_ VGND VGND VPWR VPWR _1844_ sky130_fd_sc_hd__a21o_1
XFILLER_0_66_53 VGND VGND VPWR VPWR sky130_fd_sc_hd__decap_4
X_4194_ net7 _1059_ _1035_ _1067_ VGND VGND VPWR VPWR _0173_ sky130_fd_sc_hd__o211a_1
X_3145_ fifo2.rd_pointer\[0\] _1504_ _1505_ VGND VGND VPWR VPWR _0492_ sky130_fd_sc_hd__a21oi_1
X_3076_ _0767_ _1754_ _1756_ _1757_ net54 VGND VGND VPWR VPWR _0464_ sky130_fd_sc_hd__a32o_1
XFILLER_0_89_361 VPWR VGND VPWR VGND sky130_ef_sc_hd__decap_12
XFILLER_0_9_333 VGND VGND VPWR VPWR sky130_fd_sc_hd__decap_3
XFILLER_0_17_111 VGND VGND VPWR VPWR sky130_fd_sc_hd__fill_1
X_3978_ _0919_ VGND VGND VPWR VPWR _0920_ sky130_fd_sc_hd__clkbuf_4
X_2929_ _1567_ fifo2.mem\[12\]\[4\] _0005_ VGND VGND VPWR VPWR _1633_ sky130_fd_sc_hd__o21ba_1
XFILLER_0_45_486 VPWR VGND VPWR VGND sky130_ef_sc_hd__decap_12
XFILLER_0_20_309 VGND VGND VPWR VPWR sky130_fd_sc_hd__decap_8
XFILLER_0_60_467 VGND VGND VPWR VPWR sky130_fd_sc_hd__decap_3
XFILLER_0_13_383 VGND VGND VPWR VPWR sky130_fd_sc_hd__decap_8
Xhold262 fifo2.mem\[8\]\[0\] VGND VGND VPWR VPWR net310 sky130_fd_sc_hd__dlygate4sd3_1
Xhold251 fifo2.mem\[15\]\[7\] VGND VGND VPWR VPWR net299 sky130_fd_sc_hd__dlygate4sd3_1
Xhold240 fifo1.mem\[15\]\[3\] VGND VGND VPWR VPWR net288 sky130_fd_sc_hd__dlygate4sd3_1
Xhold295 fifo3.mem\[15\]\[3\] VGND VGND VPWR VPWR net343 sky130_fd_sc_hd__dlygate4sd3_1
Xhold284 fifo3.rd_pointer\[4\] VGND VGND VPWR VPWR net332 sky130_fd_sc_hd__dlygate4sd3_1
Xhold273 fifo2.mem\[10\]\[0\] VGND VGND VPWR VPWR net321 sky130_fd_sc_hd__dlygate4sd3_1
XFILLER_0_68_512 VGND VGND VPWR VPWR sky130_fd_sc_hd__fill_1
XFILLER_0_11_15 VPWR VGND VPWR VGND sky130_ef_sc_hd__decap_12
XFILLER_0_63_272 VGND VGND VPWR VPWR sky130_fd_sc_hd__decap_8
XFILLER_0_51_445 VGND VGND VPWR VPWR sky130_fd_sc_hd__decap_3
XFILLER_0_23_169 VGND VGND VPWR VPWR sky130_fd_sc_hd__decap_4
Xinput8 data_in[7] VGND VGND VPWR VPWR net8 sky130_fd_sc_hd__buf_2
X_3901_ _0854_ VGND VGND VPWR VPWR _0870_ sky130_fd_sc_hd__buf_2
X_3832_ _0779_ fifo3.mem\[8\]\[7\] _0800_ VGND VGND VPWR VPWR _0819_ sky130_fd_sc_hd__and3_1
X_3763_ fifo1.temp VGND VGND VPWR VPWR _0767_ sky130_fd_sc_hd__buf_4
XFILLER_0_42_401 VPWR VGND VPWR VGND sky130_ef_sc_hd__decap_12
X_2714_ _1482_ VGND VGND VPWR VPWR _1483_ sky130_fd_sc_hd__clkbuf_4
X_3694_ _0714_ VGND VGND VPWR VPWR _0715_ sky130_fd_sc_hd__clkbuf_4
XFILLER_0_2_531 VGND VGND VPWR VPWR sky130_fd_sc_hd__fill_1
X_2645_ _0761_ _0981_ _1446_ _1455_ VGND VGND VPWR VPWR _0335_ sky130_fd_sc_hd__a31o_1
XFILLER_0_22_180 VGND VGND VPWR VPWR sky130_fd_sc_hd__decap_4
X_4315_ clknet_leaf_28_clock _0129_ VGND VGND VPWR VPWR fifo2.mem\[1\]\[6\] sky130_fd_sc_hd__dfxtp_1
X_2576_ _0732_ _1431_ _1433_ _1432_ net121 VGND VGND VPWR VPWR _0288_ sky130_fd_sc_hd__a32o_1
X_4246_ clknet_leaf_55_clock _0060_ VGND VGND VPWR VPWR fifo3.mem\[8\]\[7\] sky130_fd_sc_hd__dfxtp_1
X_4177_ regis.internal_parity\[7\] _1056_ _1057_ VGND VGND VPWR VPWR _0166_ sky130_fd_sc_hd__o21a_1
X_3128_ _0925_ _1789_ _1790_ VGND VGND VPWR VPWR _0483_ sky130_fd_sc_hd__o21a_1
XTAP_1029 VGND VPWR sky130_fd_sc_hd__tapvpwrvgnd_1
XTAP_1018 VGND VPWR sky130_fd_sc_hd__tapvpwrvgnd_1
XTAP_1007 VGND VPWR sky130_fd_sc_hd__tapvpwrvgnd_1
X_3059_ net237 _1749_ _1751_ _0764_ VGND VGND VPWR VPWR _0453_ sky130_fd_sc_hd__a22o_1
XFILLER_0_77_353 VPWR VGND VPWR VGND sky130_ef_sc_hd__decap_12
XFILLER_0_77_386 VGND VGND VPWR VPWR sky130_fd_sc_hd__decap_6
XFILLER_0_9_130 VGND VGND VPWR VPWR sky130_fd_sc_hd__fill_1
XFILLER_0_65_537 VGND VGND VPWR VPWR sky130_fd_sc_hd__decap_4
XFILLER_0_33_401 VGND VGND VPWR VPWR sky130_fd_sc_hd__decap_3
XFILLER_0_45_272 VGND VGND VPWR VPWR sky130_fd_sc_hd__fill_1
XFILLER_0_68_353 VGND VGND VPWR VPWR sky130_fd_sc_hd__decap_8
XPHY_70 VGND VGND VPWR VPWR sky130_fd_sc_hd__decap_3
XPHY_81 VGND VGND VPWR VPWR sky130_fd_sc_hd__decap_3
XPHY_92 VGND VGND VPWR VPWR sky130_fd_sc_hd__decap_3
XFILLER_0_56_537 VGND VGND VPWR VPWR sky130_fd_sc_hd__decap_4
XFILLER_0_24_401 VGND VGND VPWR VPWR sky130_fd_sc_hd__decap_3
XFILLER_0_51_253 VPWR VGND VPWR VGND sky130_ef_sc_hd__decap_12
X_2430_ _1314_ _1185_ _1198_ VGND VGND VPWR VPWR _1315_ sky130_fd_sc_hd__a21oi_1
X_2361_ fifo1.mem\[11\]\[3\] _1220_ _1247_ VGND VGND VPWR VPWR _1248_ sky130_fd_sc_hd__o21ai_1
X_2292_ _1175_ _1179_ VGND VGND VPWR VPWR _1180_ sky130_fd_sc_hd__nand2_1
X_4100_ _0993_ fifo1.data_in\[2\] VGND VGND VPWR VPWR _1003_ sky130_fd_sc_hd__or2b_1
X_4031_ _0954_ VGND VGND VPWR VPWR _0955_ sky130_fd_sc_hd__clkbuf_4
XFILLER_0_2_46 VPWR VGND VPWR VGND sky130_ef_sc_hd__decap_12
Xclkbuf_leaf_34_clock clknet_3_7__leaf_clock VGND VGND VPWR VPWR clknet_leaf_34_clock
+ sky130_fd_sc_hd__clkbuf_16
XFILLER_0_78_139 VGND VGND VPWR VPWR sky130_fd_sc_hd__fill_1
Xclkbuf_leaf_49_clock clknet_3_4__leaf_clock VGND VGND VPWR VPWR clknet_leaf_49_clock
+ sky130_fd_sc_hd__clkbuf_16
XFILLER_0_47_537 VGND VGND VPWR VPWR sky130_fd_sc_hd__decap_4
X_4795_ clknet_leaf_56_clock _0601_ VGND VGND VPWR VPWR fifo3.mem\[13\]\[5\] sky130_fd_sc_hd__dfxtp_1
X_3815_ _0807_ _0731_ _0805_ VGND VGND VPWR VPWR _0808_ sky130_fd_sc_hd__mux2_1
X_3746_ _0757_ _0755_ VGND VGND VPWR VPWR _0758_ sky130_fd_sc_hd__nor2_4
XFILLER_0_12_80 VGND VGND VPWR VPWR sky130_fd_sc_hd__decap_4
X_3677_ syn.count0\[0\] syn.count0\[1\] syn.count0\[2\] VGND VGND VPWR VPWR _0702_
+ sky130_fd_sc_hd__a21oi_1
XFILLER_0_30_415 VGND VGND VPWR VPWR sky130_fd_sc_hd__decap_4
XFILLER_0_42_286 VGND VGND VPWR VPWR sky130_fd_sc_hd__fill_1
X_2628_ net317 _0963_ _1442_ _1444_ _0743_ VGND VGND VPWR VPWR _0329_ sky130_fd_sc_hd__a32o_1
XFILLER_0_2_361 VGND VGND VPWR VPWR sky130_fd_sc_hd__decap_3
XFILLER_0_10_150 VGND VGND VPWR VPWR sky130_fd_sc_hd__fill_2
Xclkbuf_3_4__f_clock clknet_0_clock VGND VGND VPWR VPWR clknet_3_4__leaf_clock sky130_fd_sc_hd__clkbuf_16
X_2559_ fifo2.wr_pointer\[3\] _0619_ _0718_ _0853_ VGND VGND VPWR VPWR _1427_ sky130_fd_sc_hd__and4_2
X_4229_ clknet_leaf_13_clock _0043_ VGND VGND VPWR VPWR fifo1.mem\[0\]\[8\] sky130_fd_sc_hd__dfxtp_1
Xmax_cap48 _0657_ VGND VGND VPWR VPWR net48 sky130_fd_sc_hd__clkbuf_1
XFILLER_0_69_128 VGND VGND VPWR VPWR sky130_fd_sc_hd__fill_2
XFILLER_0_77_194 VGND VGND VPWR VPWR sky130_fd_sc_hd__decap_4
XFILLER_0_33_242 VPWR VGND VPWR VGND sky130_ef_sc_hd__decap_12
XFILLER_0_61_540 VGND VGND VPWR VPWR sky130_fd_sc_hd__fill_1
XFILLER_0_0_309 VPWR VGND VPWR VGND sky130_ef_sc_hd__decap_12
XFILLER_0_33_297 VGND VGND VPWR VPWR sky130_fd_sc_hd__fill_2
XFILLER_0_17_14 VPWR VGND VPWR VGND sky130_ef_sc_hd__decap_12
XFILLER_0_33_57 VPWR VGND VPWR VGND sky130_ef_sc_hd__decap_12
XFILLER_0_83_175 VGND VGND VPWR VPWR sky130_fd_sc_hd__fill_1
XFILLER_0_83_164 VGND VGND VPWR VPWR sky130_fd_sc_hd__decap_4
XFILLER_0_16_209 VGND VGND VPWR VPWR sky130_fd_sc_hd__fill_1
Xinput11 read_enb_1 VGND VGND VPWR VPWR net11 sky130_fd_sc_hd__clkbuf_4
X_3600_ fifo3.wr_pointer\[0\] _0637_ VGND VGND VPWR VPWR _0638_ sky130_fd_sc_hd__or2b_1
X_4580_ clknet_leaf_9_clock _0386_ VGND VGND VPWR VPWR fifo1.mem\[11\]\[0\] sky130_fd_sc_hd__dfxtp_1
X_3531_ _1772_ _1420_ _1774_ _1775_ fifo3.mem\[11\]\[2\] VGND VGND VPWR VPWR _2097_
+ sky130_fd_sc_hd__o311ai_1
XFILLER_0_24_253 VGND VGND VPWR VPWR sky130_fd_sc_hd__decap_3
XFILLER_0_3_169 VGND VGND VPWR VPWR sky130_fd_sc_hd__decap_6
X_3462_ _2049_ fifo3.count\[5\] VGND VGND VPWR VPWR _2063_ sky130_fd_sc_hd__nand2_1
X_3393_ _2003_ VGND VGND VPWR VPWR _0535_ sky130_fd_sc_hd__clkbuf_1
X_2413_ _1294_ _1295_ _1297_ VGND VGND VPWR VPWR _1298_ sky130_fd_sc_hd__a21oi_1
X_2344_ _1229_ _1230_ _1195_ VGND VGND VPWR VPWR _1231_ sky130_fd_sc_hd__a21oi_1
X_2275_ _1164_ _1165_ _0874_ VGND VGND VPWR VPWR _1166_ sky130_fd_sc_hd__and3_1
X_4014_ fifo3.mem\[6\]\[1\] _0944_ _0942_ VGND VGND VPWR VPWR _0946_ sky130_fd_sc_hd__a21bo_1
XFILLER_0_79_437 VGND VGND VPWR VPWR sky130_fd_sc_hd__fill_2
XFILLER_0_90_41 VPWR VGND VPWR VGND sky130_ef_sc_hd__decap_12
XFILLER_0_90_85 VPWR VGND VPWR VGND sky130_ef_sc_hd__decap_12
XFILLER_0_59_194 VPWR VGND VPWR VGND sky130_ef_sc_hd__decap_12
XFILLER_0_74_175 VGND VGND VPWR VPWR sky130_fd_sc_hd__decap_3
XFILLER_0_74_153 VGND VGND VPWR VPWR sky130_fd_sc_hd__decap_6
XFILLER_0_35_529 VGND VGND VPWR VPWR sky130_fd_sc_hd__decap_8
X_4778_ clknet_leaf_58_clock _0584_ VGND VGND VPWR VPWR fifo3.mem\[11\]\[6\] sky130_fd_sc_hd__dfxtp_1
XFILLER_0_62_359 VGND VGND VPWR VPWR sky130_fd_sc_hd__decap_4
X_3729_ _0743_ _0715_ _0741_ _0730_ net154 VGND VGND VPWR VPWR _0032_ sky130_fd_sc_hd__a32o_1
XFILLER_0_65_175 VGND VGND VPWR VPWR sky130_fd_sc_hd__decap_6
XFILLER_0_53_337 VPWR VGND VPWR VGND sky130_ef_sc_hd__decap_12
XFILLER_0_65_197 VGND VGND VPWR VPWR sky130_fd_sc_hd__decap_6
XFILLER_0_21_212 VGND VGND VPWR VPWR sky130_fd_sc_hd__fill_2
XFILLER_0_21_223 VGND VGND VPWR VPWR sky130_fd_sc_hd__fill_1
XFILLER_0_21_267 VGND VGND VPWR VPWR sky130_fd_sc_hd__fill_2
XTAP_407 VGND VPWR sky130_fd_sc_hd__tapvpwrvgnd_1
XTAP_418 VGND VPWR sky130_fd_sc_hd__tapvpwrvgnd_1
XTAP_429 VGND VPWR sky130_fd_sc_hd__tapvpwrvgnd_1
XFILLER_0_88_245 VGND VGND VPWR VPWR sky130_fd_sc_hd__decap_6
XFILLER_0_8_206 VGND VGND VPWR VPWR sky130_fd_sc_hd__decap_4
XFILLER_0_29_334 VGND VGND VPWR VPWR sky130_fd_sc_hd__fill_2
X_2962_ fifo2.mem\[5\]\[5\] VGND VGND VPWR VPWR _1665_ sky130_fd_sc_hd__inv_2
XFILLER_0_84_473 VGND VGND VPWR VPWR sky130_fd_sc_hd__decap_3
XFILLER_0_17_529 VPWR VGND VPWR VGND sky130_ef_sc_hd__decap_12
XFILLER_0_44_315 VGND VGND VPWR VPWR sky130_fd_sc_hd__fill_1
X_4701_ clknet_leaf_19_clock _0507_ VGND VGND VPWR VPWR fifo1.mem\[14\]\[2\] sky130_fd_sc_hd__dfxtp_1
X_4632_ clknet_leaf_0_clock _0438_ VGND VGND VPWR VPWR net21 sky130_fd_sc_hd__dfxtp_1
XFILLER_0_60_77 VGND VGND VPWR VPWR sky130_fd_sc_hd__decap_6
X_2893_ _1594_ _1595_ _1596_ _1597_ VGND VGND VPWR VPWR _1598_ sky130_fd_sc_hd__o22ai_2
XFILLER_0_4_401 VPWR VGND VPWR VGND sky130_ef_sc_hd__decap_12
XFILLER_0_4_456 VGND VGND VPWR VPWR sky130_fd_sc_hd__decap_3
X_4563_ clknet_leaf_21_clock _0369_ VGND VGND VPWR VPWR fifo2.mem\[5\]\[1\] sky130_fd_sc_hd__dfxtp_1
X_3514_ _1760_ _1779_ _1781_ fifo3.mem\[10\]\[3\] _1783_ VGND VGND VPWR VPWR _2088_
+ sky130_fd_sc_hd__o311a_1
XFILLER_0_4_489 VPWR VGND VPWR VGND sky130_ef_sc_hd__decap_12
X_4494_ clknet_leaf_35_clock _0300_ VGND VGND VPWR VPWR fifo2.mem\[12\]\[4\] sky130_fd_sc_hd__dfxtp_1
X_3445_ _2032_ _2046_ _2047_ _2034_ _2019_ VGND VGND VPWR VPWR _2048_ sky130_fd_sc_hd__o221ai_2
XTAP_952 VGND VPWR sky130_fd_sc_hd__tapvpwrvgnd_1
X_3376_ fifo2.mem\[0\]\[0\] fifo2.mem\[1\]\[0\] fifo2.mem\[2\]\[0\] fifo2.mem\[3\]\[0\]
+ _1669_ _1702_ VGND VGND VPWR VPWR _1990_ sky130_fd_sc_hd__mux4_1
XTAP_941 VGND VPWR sky130_fd_sc_hd__tapvpwrvgnd_1
XTAP_930 VGND VPWR sky130_fd_sc_hd__tapvpwrvgnd_1
XTAP_996 VGND VPWR sky130_fd_sc_hd__tapvpwrvgnd_1
XTAP_985 VGND VPWR sky130_fd_sc_hd__tapvpwrvgnd_1
XTAP_974 VGND VPWR sky130_fd_sc_hd__tapvpwrvgnd_1
XTAP_963 VGND VPWR sky130_fd_sc_hd__tapvpwrvgnd_1
X_2327_ _1176_ fifo1.mem\[14\]\[2\] _1178_ VGND VGND VPWR VPWR _1215_ sky130_fd_sc_hd__o21ai_1
XFILLER_0_33_3 VPWR VGND VPWR VGND sky130_ef_sc_hd__decap_12
X_2258_ _1151_ VGND VGND VPWR VPWR _1152_ sky130_fd_sc_hd__clkbuf_4
X_2189_ _1106_ _1117_ _1118_ net158 VGND VGND VPWR VPWR _0216_ sky130_fd_sc_hd__a22o_1
XFILLER_0_35_337 VPWR VGND VPWR VGND sky130_ef_sc_hd__decap_12
XFILLER_0_14_15 VPWR VGND VPWR VGND sky130_ef_sc_hd__decap_12
XFILLER_0_85_237 VPWR VGND VPWR VGND sky130_ef_sc_hd__decap_12
XFILLER_0_38_164 VPWR VGND VPWR VGND sky130_ef_sc_hd__decap_12
XFILLER_0_66_473 VGND VGND VPWR VPWR sky130_fd_sc_hd__decap_3
XFILLER_0_5_209 VGND VGND VPWR VPWR sky130_fd_sc_hd__decap_4
XFILLER_0_38_197 VGND VGND VPWR VPWR sky130_fd_sc_hd__fill_2
XTAP_204 VGND VPWR sky130_fd_sc_hd__tapvpwrvgnd_1
XTAP_215 VGND VPWR sky130_fd_sc_hd__tapvpwrvgnd_1
XTAP_248 VGND VPWR sky130_fd_sc_hd__tapvpwrvgnd_1
XTAP_226 VGND VPWR sky130_fd_sc_hd__tapvpwrvgnd_1
XTAP_237 VGND VPWR sky130_fd_sc_hd__tapvpwrvgnd_1
X_3230_ _1855_ _1859_ _0010_ VGND VGND VPWR VPWR _1860_ sky130_fd_sc_hd__o21ai_2
XTAP_259 VGND VPWR sky130_fd_sc_hd__tapvpwrvgnd_1
X_3161_ _1119_ _1122_ _1800_ VGND VGND VPWR VPWR _1802_ sky130_fd_sc_hd__and3_1
X_2112_ regis.internal_parity\[2\] VGND VGND VPWR VPWR _1083_ sky130_fd_sc_hd__inv_2
X_3092_ _1759_ _1419_ _0835_ _0782_ fifo3.mem\[2\]\[6\] VGND VGND VPWR VPWR _1767_
+ sky130_fd_sc_hd__o311a_1
XFILLER_0_76_215 VPWR VGND VPWR VGND sky130_ef_sc_hd__decap_12
XFILLER_0_71_43 VGND VGND VPWR VPWR sky130_fd_sc_hd__fill_2
X_3994_ _0737_ VGND VGND VPWR VPWR _0932_ sky130_fd_sc_hd__buf_4
X_2945_ _1550_ fifo2.mem\[4\]\[4\] _1558_ VGND VGND VPWR VPWR _1649_ sky130_fd_sc_hd__o21bai_1
X_2876_ _1572_ VGND VGND VPWR VPWR _1582_ sky130_fd_sc_hd__clkbuf_4
XFILLER_0_44_189 VGND VGND VPWR VPWR sky130_fd_sc_hd__decap_6
X_4615_ clknet_leaf_5_clock _0421_ VGND VGND VPWR VPWR fifo1.mem\[4\]\[8\] sky130_fd_sc_hd__dfxtp_1
X_4546_ clknet_leaf_19_clock _0352_ VGND VGND VPWR VPWR fifo1.mem\[13\]\[2\] sky130_fd_sc_hd__dfxtp_1
XFILLER_0_4_253 VGND VGND VPWR VPWR sky130_fd_sc_hd__fill_2
XFILLER_0_20_80 VGND VGND VPWR VPWR sky130_fd_sc_hd__decap_4
X_4477_ clknet_leaf_37_clock _0283_ VGND VGND VPWR VPWR fifo2.mem\[14\]\[5\] sky130_fd_sc_hd__dfxtp_1
X_3428_ _1845_ _1861_ _1891_ _1878_ VGND VGND VPWR VPWR _2032_ sky130_fd_sc_hd__nand4_4
X_3359_ _0823_ _0831_ _0784_ _0833_ VGND VGND VPWR VPWR _1981_ sky130_fd_sc_hd__a31o_1
XTAP_760 VGND VPWR sky130_fd_sc_hd__tapvpwrvgnd_1
XTAP_771 VGND VPWR sky130_fd_sc_hd__tapvpwrvgnd_1
XTAP_782 VGND VPWR sky130_fd_sc_hd__tapvpwrvgnd_1
XTAP_793 VGND VPWR sky130_fd_sc_hd__tapvpwrvgnd_1
XFILLER_0_48_462 VGND VGND VPWR VPWR sky130_fd_sc_hd__fill_2
XFILLER_0_75_281 VGND VGND VPWR VPWR sky130_fd_sc_hd__decap_6
XFILLER_0_63_432 VGND VGND VPWR VPWR sky130_fd_sc_hd__decap_8
XFILLER_0_90_251 VGND VGND VPWR VPWR sky130_fd_sc_hd__fill_1
XFILLER_0_35_167 VGND VGND VPWR VPWR sky130_fd_sc_hd__fill_1
XFILLER_0_86_513 VPWR VGND VPWR VGND sky130_ef_sc_hd__decap_12
XFILLER_0_41_57 VPWR VGND VPWR VGND sky130_ef_sc_hd__decap_12
XFILLER_0_26_156 VGND VGND VPWR VPWR sky130_fd_sc_hd__decap_4
X_2730_ _1105_ _1485_ _1486_ net142 VGND VGND VPWR VPWR _0389_ sky130_fd_sc_hd__a22o_1
XFILLER_0_14_307 VGND VGND VPWR VPWR sky130_fd_sc_hd__fill_1
X_2661_ _1104_ _1462_ _1463_ net278 VGND VGND VPWR VPWR _0343_ sky130_fd_sc_hd__a22o_1
XFILLER_0_41_148 VGND VGND VPWR VPWR sky130_fd_sc_hd__decap_4
X_4400_ clknet_leaf_9_clock _0214_ VGND VGND VPWR VPWR fifo1.mem\[8\]\[2\] sky130_fd_sc_hd__dfxtp_1
X_2592_ _0744_ _0851_ _1428_ _1434_ net226 VGND VGND VPWR VPWR _0303_ sky130_fd_sc_hd__a32o_1
X_4331_ clknet_leaf_43_clock _0145_ VGND VGND VPWR VPWR fifo1.data_in\[3\] sky130_fd_sc_hd__dfxtp_1
XFILLER_0_1_278 VGND VGND VPWR VPWR sky130_fd_sc_hd__fill_2
X_4262_ clknet_leaf_41_clock _0076_ VGND VGND VPWR VPWR fifo2.mem\[8\]\[5\] sky130_fd_sc_hd__dfxtp_1
XFILLER_0_5_57 VPWR VGND VPWR VGND sky130_ef_sc_hd__decap_12
X_3213_ _1838_ fifo3.mem\[13\]\[2\] _1842_ VGND VGND VPWR VPWR _1843_ sky130_fd_sc_hd__o21ai_1
XFILLER_0_66_21 VGND VGND VPWR VPWR sky130_fd_sc_hd__fill_1
X_4193_ regis.packet_parity\[6\] _0682_ VGND VGND VPWR VPWR _1067_ sky130_fd_sc_hd__or2_1
XFILLER_0_66_76 VGND VGND VPWR VPWR sky130_fd_sc_hd__fill_1
X_3144_ _0939_ _1789_ _1798_ VGND VGND VPWR VPWR _0491_ sky130_fd_sc_hd__o21a_1
XFILLER_0_66_98 VGND VGND VPWR VPWR sky130_fd_sc_hd__decap_8
X_3075_ _0765_ _1754_ _1756_ _1757_ net152 VGND VGND VPWR VPWR _0463_ sky130_fd_sc_hd__a32o_1
XFILLER_0_89_373 VGND VGND VPWR VPWR sky130_fd_sc_hd__fill_2
X_3977_ _0823_ _0831_ _0769_ VGND VGND VPWR VPWR _0919_ sky130_fd_sc_hd__and3b_1
XFILLER_0_45_443 VGND VGND VPWR VPWR sky130_fd_sc_hd__decap_4
X_2928_ _1615_ _1610_ _1630_ _1631_ VGND VGND VPWR VPWR _1632_ sky130_fd_sc_hd__o2bb2ai_1
XFILLER_0_72_251 VGND VGND VPWR VPWR sky130_fd_sc_hd__fill_1
XFILLER_0_17_167 VGND VGND VPWR VPWR sky130_fd_sc_hd__fill_1
XFILLER_0_45_465 VPWR VGND VPWR VGND sky130_ef_sc_hd__decap_12
XFILLER_0_45_498 VGND VGND VPWR VPWR sky130_fd_sc_hd__decap_6
XFILLER_0_32_126 VGND VGND VPWR VPWR sky130_fd_sc_hd__fill_1
X_2859_ _1560_ _1564_ _0006_ VGND VGND VPWR VPWR _1565_ sky130_fd_sc_hd__o21ai_2
Xhold241 fifo3.mem\[15\]\[2\] VGND VGND VPWR VPWR net289 sky130_fd_sc_hd__dlygate4sd3_1
X_4529_ clknet_leaf_22_clock _0335_ VGND VGND VPWR VPWR fifo2.mem\[7\]\[3\] sky130_fd_sc_hd__dfxtp_1
Xhold252 fifo2.mem\[5\]\[6\] VGND VGND VPWR VPWR net300 sky130_fd_sc_hd__dlygate4sd3_1
Xhold230 fifo1.mem\[12\]\[2\] VGND VGND VPWR VPWR net278 sky130_fd_sc_hd__dlygate4sd3_1
Xhold296 fifo3.mem\[12\]\[6\] VGND VGND VPWR VPWR net344 sky130_fd_sc_hd__dlygate4sd3_1
Xhold263 fifo3.mem\[12\]\[5\] VGND VGND VPWR VPWR net311 sky130_fd_sc_hd__dlygate4sd3_1
Xhold285 fifo2.mem\[5\]\[4\] VGND VGND VPWR VPWR net333 sky130_fd_sc_hd__dlygate4sd3_1
Xhold274 fifo1.mem\[15\]\[4\] VGND VGND VPWR VPWR net322 sky130_fd_sc_hd__dlygate4sd3_1
XTAP_590 VGND VPWR sky130_fd_sc_hd__tapvpwrvgnd_1
XFILLER_0_83_505 VPWR VGND VPWR VGND sky130_ef_sc_hd__decap_12
XFILLER_0_36_421 VGND VGND VPWR VPWR sky130_fd_sc_hd__decap_8
XFILLER_0_48_292 VPWR VGND VPWR VGND sky130_ef_sc_hd__decap_12
XFILLER_0_11_27 VPWR VGND VPWR VGND sky130_ef_sc_hd__decap_12
Xinput9 pkt_valid VGND VGND VPWR VPWR net9 sky130_fd_sc_hd__clkbuf_2
XFILLER_0_86_365 VPWR VGND VPWR VGND sky130_ef_sc_hd__decap_12
X_3900_ _0851_ VGND VGND VPWR VPWR _0869_ sky130_fd_sc_hd__clkbuf_4
X_3831_ _0818_ VGND VGND VPWR VPWR _0059_ sky130_fd_sc_hd__clkbuf_1
X_3762_ _0766_ _0755_ _0758_ net208 VGND VGND VPWR VPWR _0042_ sky130_fd_sc_hd__a22o_1
XFILLER_0_39_281 VGND VGND VPWR VPWR sky130_fd_sc_hd__decap_6
XFILLER_0_42_413 VGND VGND VPWR VPWR sky130_fd_sc_hd__fill_2
XFILLER_0_14_115 VGND VGND VPWR VPWR sky130_fd_sc_hd__fill_1
X_2713_ _0769_ _0772_ _0780_ _0803_ VGND VGND VPWR VPWR _1482_ sky130_fd_sc_hd__and4_1
X_3693_ fifo2.wr_pointer\[1\] fifo2.wr_pointer\[0\] VGND VGND VPWR VPWR _0714_ sky130_fd_sc_hd__and2_1
X_2644_ _1447_ _1448_ _1450_ _1451_ fifo2.mem\[7\]\[3\] VGND VGND VPWR VPWR _1455_
+ sky130_fd_sc_hd__o311a_1
XFILLER_0_77_20 VGND VGND VPWR VPWR sky130_fd_sc_hd__fill_1
X_2575_ _1428_ VGND VGND VPWR VPWR _1433_ sky130_fd_sc_hd__clkbuf_4
X_4314_ clknet_leaf_26_clock _0128_ VGND VGND VPWR VPWR fifo2.mem\[1\]\[5\] sky130_fd_sc_hd__dfxtp_1
XFILLER_0_10_376 VPWR VGND VPWR VGND sky130_ef_sc_hd__decap_12
X_4245_ clknet_leaf_54_clock _0059_ VGND VGND VPWR VPWR fifo3.mem\[8\]\[6\] sky130_fd_sc_hd__dfxtp_1
X_4176_ _1056_ regis.internal_parity\[7\] _0874_ VGND VGND VPWR VPWR _1057_ sky130_fd_sc_hd__a21boi_1
X_3127_ fifo3.mem\[4\]\[0\] _0842_ _1789_ VGND VGND VPWR VPWR _1790_ sky130_fd_sc_hd__a21bo_1
XTAP_1019 VGND VPWR sky130_fd_sc_hd__tapvpwrvgnd_1
XTAP_1008 VGND VPWR sky130_fd_sc_hd__tapvpwrvgnd_1
X_3058_ fifo2.mem\[6\]\[5\] _1749_ _1751_ _0934_ VGND VGND VPWR VPWR _0452_ sky130_fd_sc_hd__a22o_1
XFILLER_0_77_365 VGND VGND VPWR VPWR sky130_fd_sc_hd__decap_4
XFILLER_0_37_207 VGND VGND VPWR VPWR sky130_fd_sc_hd__fill_1
XFILLER_0_9_175 VGND VGND VPWR VPWR sky130_fd_sc_hd__decap_4
XFILLER_0_18_421 VPWR VGND VPWR VGND sky130_ef_sc_hd__decap_12
XFILLER_0_5_381 VGND VGND VPWR VPWR sky130_fd_sc_hd__decap_8
XFILLER_0_60_243 VGND VGND VPWR VPWR sky130_fd_sc_hd__fill_1
XFILLER_0_13_192 VGND VGND VPWR VPWR sky130_fd_sc_hd__fill_2
Xclkbuf_leaf_0_clock clknet_3_0__leaf_clock VGND VGND VPWR VPWR clknet_leaf_0_clock
+ sky130_fd_sc_hd__clkbuf_16
XPHY_60 VGND VGND VPWR VPWR sky130_fd_sc_hd__decap_3
XPHY_71 VGND VGND VPWR VPWR sky130_fd_sc_hd__decap_3
XPHY_82 VGND VGND VPWR VPWR sky130_fd_sc_hd__decap_3
XPHY_93 VGND VGND VPWR VPWR sky130_fd_sc_hd__decap_3
XFILLER_0_24_435 VPWR VGND VPWR VGND sky130_ef_sc_hd__decap_12
XFILLER_0_51_265 VGND VGND VPWR VPWR sky130_fd_sc_hd__decap_4
XFILLER_0_11_107 VGND VGND VPWR VPWR sky130_fd_sc_hd__decap_4
X_2360_ _1221_ fifo1.mem\[10\]\[3\] _1182_ VGND VGND VPWR VPWR _1247_ sky130_fd_sc_hd__o21a_1
X_2291_ fifo1.mem\[8\]\[8\] fifo1.mem\[9\]\[8\] fifo1.mem\[10\]\[8\] fifo1.mem\[11\]\[8\]
+ _1176_ _1178_ VGND VGND VPWR VPWR _1179_ sky130_fd_sc_hd__mux4_2
X_4030_ _0726_ fifo2.wr_pointer\[0\] VGND VGND VPWR VPWR _0954_ sky130_fd_sc_hd__and2b_1
XFILLER_0_2_58 VPWR VGND VPWR VGND sky130_ef_sc_hd__decap_12
XFILLER_0_47_505 VGND VGND VPWR VPWR sky130_fd_sc_hd__decap_3
X_4794_ clknet_leaf_55_clock _0600_ VGND VGND VPWR VPWR fifo3.mem\[13\]\[4\] sky130_fd_sc_hd__dfxtp_1
XFILLER_0_6_134 VGND VGND VPWR VPWR sky130_fd_sc_hd__decap_6
X_3814_ _0799_ fifo3.mem\[8\]\[1\] _0800_ VGND VGND VPWR VPWR _0807_ sky130_fd_sc_hd__and3_1
XFILLER_0_62_519 VPWR VGND VPWR VGND sky130_ef_sc_hd__decap_12
X_3745_ _0756_ VGND VGND VPWR VPWR _0757_ sky130_fd_sc_hd__clkbuf_8
XFILLER_0_70_530 VGND VGND VPWR VPWR sky130_fd_sc_hd__fill_2
XFILLER_0_88_41 VPWR VGND VPWR VGND sky130_ef_sc_hd__decap_12
X_3676_ _0698_ _0701_ VGND VGND VPWR VPWR _0021_ sky130_fd_sc_hd__nor2_1
XFILLER_0_88_85 VPWR VGND VPWR VGND sky130_ef_sc_hd__decap_12
XFILLER_0_30_449 VGND VGND VPWR VPWR sky130_fd_sc_hd__fill_1
X_2627_ net323 _1437_ _1442_ _1444_ _0740_ VGND VGND VPWR VPWR _0328_ sky130_fd_sc_hd__a32o_1
XFILLER_0_63_3 VGND VGND VPWR VPWR sky130_fd_sc_hd__fill_1
X_2558_ _1425_ VGND VGND VPWR VPWR _1426_ sky130_fd_sc_hd__clkbuf_4
X_2489_ _1187_ _1371_ VGND VGND VPWR VPWR _1372_ sky130_fd_sc_hd__nand2_1
X_4228_ clknet_leaf_13_clock _0042_ VGND VGND VPWR VPWR fifo1.mem\[0\]\[7\] sky130_fd_sc_hd__dfxtp_1
X_4159_ regis.internal_parity\[1\] _1044_ _1045_ VGND VGND VPWR VPWR _0160_ sky130_fd_sc_hd__o21a_1
XFILLER_0_65_335 VGND VGND VPWR VPWR sky130_fd_sc_hd__fill_1
XFILLER_0_65_357 VGND VGND VPWR VPWR sky130_fd_sc_hd__decap_3
XFILLER_0_33_254 VGND VGND VPWR VPWR sky130_fd_sc_hd__decap_8
XFILLER_0_21_438 VGND VGND VPWR VPWR sky130_fd_sc_hd__decap_4
XFILLER_0_17_26 VGND VGND VPWR VPWR sky130_fd_sc_hd__decap_6
XFILLER_0_29_505 VPWR VGND VPWR VGND sky130_ef_sc_hd__decap_12
XFILLER_0_33_69 VGND VGND VPWR VPWR sky130_fd_sc_hd__decap_8
Xinput12 read_enb_2 VGND VGND VPWR VPWR net12 sky130_fd_sc_hd__clkbuf_4
X_3530_ _0926_ _2094_ _2096_ VGND VGND VPWR VPWR _0579_ sky130_fd_sc_hd__a21bo_1
XFILLER_0_24_298 VGND VGND VPWR VPWR sky130_fd_sc_hd__decap_8
X_3461_ fifo3.count\[5\] fifo3.count\[4\] fifo3.count\[3\] _2036_ VGND VGND VPWR VPWR
+ _2062_ sky130_fd_sc_hd__or4_1
X_3392_ _1616_ _1042_ VGND VGND VPWR VPWR _2003_ sky130_fd_sc_hd__and2_1
X_2412_ _1296_ fifo1.mem\[4\]\[5\] _1233_ VGND VGND VPWR VPWR _1297_ sky130_fd_sc_hd__o21bai_1
X_2343_ fifo1.count\[1\] fifo1.count\[0\] net10 net40 VGND VGND VPWR VPWR _1230_ sky130_fd_sc_hd__or4bb_1
X_4013_ _0925_ _0943_ _0945_ VGND VGND VPWR VPWR _0114_ sky130_fd_sc_hd__o21a_1
X_2274_ fifo1.rd_pointer\[2\] fifo1.rd_pointer\[1\] _1155_ _1160_ VGND VGND VPWR VPWR
+ _1165_ sky130_fd_sc_hd__nand4_1
XFILLER_0_90_53 VPWR VGND VPWR VGND sky130_ef_sc_hd__decap_12
XFILLER_0_90_97 VPWR VGND VPWR VGND sky130_ef_sc_hd__decap_12
XFILLER_0_59_184 VGND VGND VPWR VPWR sky130_fd_sc_hd__decap_4
XFILLER_0_7_421 VGND VGND VPWR VPWR sky130_fd_sc_hd__fill_1
XFILLER_0_62_305 VGND VGND VPWR VPWR sky130_fd_sc_hd__decap_3
X_4777_ clknet_leaf_57_clock _0583_ VGND VGND VPWR VPWR fifo3.mem\[11\]\[5\] sky130_fd_sc_hd__dfxtp_1
XFILLER_0_55_390 VGND VGND VPWR VPWR sky130_fd_sc_hd__fill_2
X_3728_ _0742_ VGND VGND VPWR VPWR _0743_ sky130_fd_sc_hd__clkbuf_8
XFILLER_0_70_382 VGND VGND VPWR VPWR sky130_fd_sc_hd__decap_6
X_3659_ _0689_ VGND VGND VPWR VPWR _0017_ sky130_fd_sc_hd__clkbuf_1
XFILLER_0_38_357 VGND VGND VPWR VPWR sky130_fd_sc_hd__decap_6
XFILLER_0_53_305 VPWR VGND VPWR VGND sky130_ef_sc_hd__decap_12
XFILLER_0_80_113 VGND VGND VPWR VPWR sky130_fd_sc_hd__fill_1
XFILLER_0_53_349 VGND VGND VPWR VPWR sky130_fd_sc_hd__fill_2
Xclkbuf_leaf_33_clock clknet_3_7__leaf_clock VGND VGND VPWR VPWR clknet_leaf_33_clock
+ sky130_fd_sc_hd__clkbuf_16
XFILLER_0_61_393 VGND VGND VPWR VPWR sky130_fd_sc_hd__decap_8
XFILLER_0_21_257 VGND VGND VPWR VPWR sky130_fd_sc_hd__decap_4
XFILLER_0_21_279 VGND VGND VPWR VPWR sky130_fd_sc_hd__fill_1
XTAP_408 VGND VPWR sky130_fd_sc_hd__tapvpwrvgnd_1
XTAP_419 VGND VPWR sky130_fd_sc_hd__tapvpwrvgnd_1
Xclkbuf_leaf_48_clock clknet_3_4__leaf_clock VGND VGND VPWR VPWR clknet_leaf_48_clock
+ sky130_fd_sc_hd__clkbuf_16
XFILLER_0_44_46 VPWR VGND VPWR VGND sky130_ef_sc_hd__decap_12
X_2961_ _1662_ _1663_ _1553_ VGND VGND VPWR VPWR _1664_ sky130_fd_sc_hd__a21o_1
X_4700_ clknet_leaf_14_clock _0506_ VGND VGND VPWR VPWR fifo1.mem\[14\]\[1\] sky130_fd_sc_hd__dfxtp_1
XFILLER_0_56_154 VGND VGND VPWR VPWR sky130_fd_sc_hd__decap_6
X_2892_ fifo2.mem\[5\]\[3\] _1567_ VGND VGND VPWR VPWR _1597_ sky130_fd_sc_hd__and2b_1
X_4631_ clknet_leaf_9_clock _0437_ VGND VGND VPWR VPWR net20 sky130_fd_sc_hd__dfxtp_1
XFILLER_0_71_113 VGND VGND VPWR VPWR sky130_fd_sc_hd__decap_8
XFILLER_0_4_413 VGND VGND VPWR VPWR sky130_fd_sc_hd__decap_6
X_4562_ clknet_leaf_21_clock _0368_ VGND VGND VPWR VPWR fifo2.mem\[5\]\[0\] sky130_fd_sc_hd__dfxtp_1
X_3513_ _0734_ _2084_ _2087_ net91 VGND VGND VPWR VPWR _0571_ sky130_fd_sc_hd__a22o_1
XFILLER_0_40_533 VGND VGND VPWR VPWR sky130_fd_sc_hd__decap_8
X_4493_ clknet_leaf_36_clock _0299_ VGND VGND VPWR VPWR fifo2.mem\[12\]\[3\] sky130_fd_sc_hd__dfxtp_1
XFILLER_0_69_43 VGND VGND VPWR VPWR sky130_fd_sc_hd__decap_4
X_3444_ _1814_ _1923_ _1929_ _1941_ VGND VGND VPWR VPWR _2047_ sky130_fd_sc_hd__o31a_1
XTAP_953 VGND VPWR sky130_fd_sc_hd__tapvpwrvgnd_1
XTAP_942 VGND VPWR sky130_fd_sc_hd__tapvpwrvgnd_1
XTAP_931 VGND VPWR sky130_fd_sc_hd__tapvpwrvgnd_1
X_3375_ fifo2.mem\[4\]\[0\] fifo2.mem\[5\]\[0\] fifo2.mem\[6\]\[0\] fifo2.mem\[7\]\[0\]
+ _1669_ _1702_ VGND VGND VPWR VPWR _1989_ sky130_fd_sc_hd__mux4_1
XTAP_920 VGND VPWR sky130_fd_sc_hd__tapvpwrvgnd_1
XTAP_986 VGND VPWR sky130_fd_sc_hd__tapvpwrvgnd_1
XTAP_975 VGND VPWR sky130_fd_sc_hd__tapvpwrvgnd_1
XTAP_964 VGND VPWR sky130_fd_sc_hd__tapvpwrvgnd_1
X_2326_ fifo1.mem\[15\]\[2\] _1188_ VGND VGND VPWR VPWR _1214_ sky130_fd_sc_hd__and2b_1
XFILLER_0_85_97 VGND VGND VPWR VPWR sky130_fd_sc_hd__fill_1
XTAP_997 VGND VPWR sky130_fd_sc_hd__tapvpwrvgnd_1
X_2257_ _1119_ _1143_ _1150_ VGND VGND VPWR VPWR _1151_ sky130_fd_sc_hd__and3_1
XFILLER_0_26_3 VPWR VGND VPWR VGND sky130_ef_sc_hd__decap_12
XFILLER_0_79_235 VGND VGND VPWR VPWR sky130_fd_sc_hd__fill_1
X_2188_ _1105_ _1117_ _1118_ net241 VGND VGND VPWR VPWR _0215_ sky130_fd_sc_hd__a22o_1
XFILLER_0_79_268 VPWR VGND VPWR VGND sky130_ef_sc_hd__decap_12
XFILLER_0_75_474 VGND VGND VPWR VPWR sky130_fd_sc_hd__decap_8
XFILLER_0_47_165 VGND VGND VPWR VPWR sky130_fd_sc_hd__decap_3
XFILLER_0_35_316 VPWR VGND VPWR VGND sky130_ef_sc_hd__decap_12
XFILLER_0_35_349 VGND VGND VPWR VPWR sky130_fd_sc_hd__decap_8
XFILLER_0_90_477 VPWR VGND VPWR VGND sky130_ef_sc_hd__decap_12
XFILLER_0_14_27 VGND VGND VPWR VPWR sky130_fd_sc_hd__fill_1
XFILLER_0_85_249 VPWR VGND VPWR VGND sky130_ef_sc_hd__decap_12
XFILLER_0_81_433 VGND VGND VPWR VPWR sky130_fd_sc_hd__fill_1
XFILLER_0_53_113 VGND VGND VPWR VPWR sky130_fd_sc_hd__decap_8
XFILLER_0_19_390 VGND VGND VPWR VPWR sky130_fd_sc_hd__fill_2
XFILLER_0_30_15 VPWR VGND VPWR VGND sky130_ef_sc_hd__decap_12
XFILLER_0_1_405 VPWR VGND VPWR VGND sky130_ef_sc_hd__decap_12
XFILLER_0_22_533 VGND VGND VPWR VPWR sky130_fd_sc_hd__decap_8
XFILLER_0_1_449 VPWR VGND VPWR VGND sky130_ef_sc_hd__decap_12
XTAP_205 VGND VPWR sky130_fd_sc_hd__tapvpwrvgnd_1
XFILLER_0_39_57 VGND VGND VPWR VPWR sky130_fd_sc_hd__fill_2
XTAP_216 VGND VPWR sky130_fd_sc_hd__tapvpwrvgnd_1
XTAP_227 VGND VPWR sky130_fd_sc_hd__tapvpwrvgnd_1
XTAP_238 VGND VPWR sky130_fd_sc_hd__tapvpwrvgnd_1
XTAP_249 VGND VPWR sky130_fd_sc_hd__tapvpwrvgnd_1
X_3160_ _1122_ _1800_ _0757_ VGND VGND VPWR VPWR _1801_ sky130_fd_sc_hd__a21oi_4
X_2111_ regis.internal_parity\[4\] VGND VGND VPWR VPWR _1082_ sky130_fd_sc_hd__inv_2
X_3091_ _0763_ _0838_ _1758_ _1766_ VGND VGND VPWR VPWR _0470_ sky130_fd_sc_hd__a31o_1
Xhold1 fifo2.mem\[3\]\[2\] VGND VGND VPWR VPWR net49 sky130_fd_sc_hd__dlygate4sd3_1
XFILLER_0_76_205 VGND VGND VPWR VPWR sky130_fd_sc_hd__decap_4
XFILLER_0_76_227 VPWR VGND VPWR VGND sky130_ef_sc_hd__decap_12
XFILLER_0_9_505 VPWR VGND VPWR VGND sky130_ef_sc_hd__decap_12
XFILLER_0_71_55 VGND VGND VPWR VPWR sky130_fd_sc_hd__fill_1
X_3993_ _0930_ _0924_ _0931_ VGND VGND VPWR VPWR _0108_ sky130_fd_sc_hd__a21o_1
X_2944_ _1645_ _1647_ _0006_ VGND VGND VPWR VPWR _1648_ sky130_fd_sc_hd__a21o_1
X_2875_ _1544_ _1580_ _0007_ VGND VGND VPWR VPWR _1581_ sky130_fd_sc_hd__o21a_1
X_4614_ clknet_leaf_5_clock _0420_ VGND VGND VPWR VPWR fifo1.mem\[4\]\[7\] sky130_fd_sc_hd__dfxtp_1
X_4545_ clknet_leaf_14_clock _0351_ VGND VGND VPWR VPWR fifo1.mem\[13\]\[1\] sky130_fd_sc_hd__dfxtp_1
XFILLER_0_4_265 VGND VGND VPWR VPWR sky130_fd_sc_hd__fill_1
XFILLER_0_25_393 VGND VGND VPWR VPWR sky130_fd_sc_hd__decap_3
X_4476_ clknet_leaf_37_clock _0282_ VGND VGND VPWR VPWR fifo2.mem\[14\]\[4\] sky130_fd_sc_hd__dfxtp_1
X_3427_ _2028_ _2031_ _0921_ VGND VGND VPWR VPWR _0541_ sky130_fd_sc_hd__a21oi_1
X_3358_ _0833_ _0784_ _0772_ VGND VGND VPWR VPWR _1980_ sky130_fd_sc_hd__and3_1
XTAP_750 VGND VPWR sky130_fd_sc_hd__tapvpwrvgnd_1
XTAP_761 VGND VPWR sky130_fd_sc_hd__tapvpwrvgnd_1
XTAP_772 VGND VPWR sky130_fd_sc_hd__tapvpwrvgnd_1
XTAP_783 VGND VPWR sky130_fd_sc_hd__tapvpwrvgnd_1
XTAP_794 VGND VPWR sky130_fd_sc_hd__tapvpwrvgnd_1
X_2309_ _0003_ VGND VGND VPWR VPWR _1197_ sky130_fd_sc_hd__inv_2
X_3289_ _1916_ VGND VGND VPWR VPWR _0518_ sky130_fd_sc_hd__clkbuf_1
XFILLER_0_0_91 VGND VGND VPWR VPWR sky130_fd_sc_hd__fill_1
XFILLER_0_35_113 VPWR VGND VPWR VGND sky130_ef_sc_hd__decap_12
XFILLER_0_16_360 VGND VGND VPWR VPWR sky130_fd_sc_hd__decap_4
XFILLER_0_35_157 VGND VGND VPWR VPWR sky130_fd_sc_hd__decap_4
XFILLER_0_50_105 VGND VGND VPWR VPWR sky130_fd_sc_hd__fill_1
XFILLER_0_86_525 VGND VGND VPWR VPWR sky130_fd_sc_hd__decap_6
XFILLER_0_25_48 VGND VGND VPWR VPWR sky130_fd_sc_hd__fill_2
XFILLER_0_26_102 VPWR VGND VPWR VGND sky130_ef_sc_hd__decap_12
XFILLER_0_41_69 VPWR VGND VPWR VGND sky130_ef_sc_hd__decap_12
X_2660_ _1098_ _1462_ _1463_ net109 VGND VGND VPWR VPWR _0342_ sky130_fd_sc_hd__a22o_1
XFILLER_0_54_477 VPWR VGND VPWR VGND sky130_ef_sc_hd__decap_12
X_2591_ _0743_ _0869_ _1428_ _1434_ net191 VGND VGND VPWR VPWR _0302_ sky130_fd_sc_hd__a32o_1
X_4330_ clknet_leaf_42_clock _0144_ VGND VGND VPWR VPWR fifo1.data_in\[2\] sky130_fd_sc_hd__dfxtp_1
X_4261_ clknet_leaf_41_clock _0075_ VGND VGND VPWR VPWR fifo2.mem\[8\]\[4\] sky130_fd_sc_hd__dfxtp_1
X_3212_ _1830_ fifo3.mem\[12\]\[2\] _1841_ VGND VGND VPWR VPWR _1842_ sky130_fd_sc_hd__o21ba_1
XFILLER_0_5_69 VPWR VGND VPWR VGND sky130_ef_sc_hd__decap_12
X_4192_ net6 _1059_ _1035_ _1066_ VGND VGND VPWR VPWR _0172_ sky130_fd_sc_hd__o211a_1
X_3143_ fifo3.mem\[4\]\[8\] _0842_ _1788_ VGND VGND VPWR VPWR _1798_ sky130_fd_sc_hd__a21bo_1
X_3074_ _0743_ _1754_ _1756_ _1757_ net147 VGND VGND VPWR VPWR _0462_ sky130_fd_sc_hd__a32o_1
XFILLER_0_77_503 VGND VGND VPWR VPWR sky130_fd_sc_hd__fill_1
XFILLER_0_17_113 VPWR VGND VPWR VGND sky130_ef_sc_hd__decap_12
X_3976_ _0918_ VGND VGND VPWR VPWR _0104_ sky130_fd_sc_hd__clkbuf_1
X_2927_ _1598_ _1542_ _1625_ VGND VGND VPWR VPWR _1631_ sky130_fd_sc_hd__a21o_1
XFILLER_0_45_477 VGND VGND VPWR VPWR sky130_fd_sc_hd__decap_4
X_2858_ _1561_ _1557_ _1563_ VGND VGND VPWR VPWR _1564_ sky130_fd_sc_hd__a21oi_1
XFILLER_0_32_149 VGND VGND VPWR VPWR sky130_fd_sc_hd__decap_4
X_2789_ fifo2.rd_pointer\[1\] fifo2.rd_pointer\[0\] VGND VGND VPWR VPWR _1507_ sky130_fd_sc_hd__nand2_1
Xhold220 fifo2.mem\[5\]\[3\] VGND VGND VPWR VPWR net268 sky130_fd_sc_hd__dlygate4sd3_1
X_4528_ clknet_leaf_23_clock _0334_ VGND VGND VPWR VPWR fifo2.mem\[7\]\[2\] sky130_fd_sc_hd__dfxtp_1
Xhold242 fifo2.mem\[15\]\[0\] VGND VGND VPWR VPWR net290 sky130_fd_sc_hd__dlygate4sd3_1
Xhold231 fifo2.mem\[11\]\[5\] VGND VGND VPWR VPWR net279 sky130_fd_sc_hd__dlygate4sd3_1
Xhold253 fifo1.mem\[9\]\[2\] VGND VGND VPWR VPWR net301 sky130_fd_sc_hd__dlygate4sd3_1
Xhold264 fifo1.mem\[3\]\[5\] VGND VGND VPWR VPWR net312 sky130_fd_sc_hd__dlygate4sd3_1
X_4459_ clknet_leaf_51_clock _0265_ VGND VGND VPWR VPWR _0008_ sky130_fd_sc_hd__dfxtp_4
Xhold275 fifo2.mem\[4\]\[5\] VGND VGND VPWR VPWR net323 sky130_fd_sc_hd__dlygate4sd3_1
Xhold286 fifo2.mem\[6\]\[3\] VGND VGND VPWR VPWR net334 sky130_fd_sc_hd__dlygate4sd3_1
Xhold297 fifo1.mem\[15\]\[5\] VGND VGND VPWR VPWR net345 sky130_fd_sc_hd__dlygate4sd3_1
XTAP_580 VGND VPWR sky130_fd_sc_hd__tapvpwrvgnd_1
XTAP_591 VGND VPWR sky130_fd_sc_hd__tapvpwrvgnd_1
XFILLER_0_83_517 VPWR VGND VPWR VGND sky130_ef_sc_hd__decap_12
XFILLER_0_11_39 VGND VGND VPWR VPWR sky130_fd_sc_hd__fill_1
XFILLER_0_36_466 VGND VGND VPWR VPWR sky130_fd_sc_hd__decap_8
XFILLER_0_36_477 VGND VGND VPWR VPWR sky130_fd_sc_hd__fill_1
XFILLER_0_63_241 VGND VGND VPWR VPWR sky130_fd_sc_hd__decap_8
XFILLER_0_51_425 VGND VGND VPWR VPWR sky130_fd_sc_hd__decap_3
XFILLER_0_51_436 VGND VGND VPWR VPWR sky130_fd_sc_hd__fill_1
XFILLER_0_16_190 VGND VGND VPWR VPWR sky130_fd_sc_hd__fill_2
XFILLER_0_86_377 VPWR VGND VPWR VGND sky130_ef_sc_hd__decap_12
X_3830_ _0817_ _0742_ _0805_ VGND VGND VPWR VPWR _0818_ sky130_fd_sc_hd__mux2_1
XFILLER_0_27_400 VGND VGND VPWR VPWR sky130_fd_sc_hd__decap_4
XFILLER_0_39_271 VGND VGND VPWR VPWR sky130_fd_sc_hd__decap_8
XFILLER_0_46_219 VGND VGND VPWR VPWR sky130_fd_sc_hd__decap_4
XFILLER_0_6_305 VGND VGND VPWR VPWR sky130_fd_sc_hd__decap_3
X_3761_ _0765_ VGND VGND VPWR VPWR _0766_ sky130_fd_sc_hd__clkbuf_8
X_2712_ _0769_ _0772_ _0803_ _0826_ VGND VGND VPWR VPWR _1481_ sky130_fd_sc_hd__a31oi_4
X_3692_ _0712_ VGND VGND VPWR VPWR _0713_ sky130_fd_sc_hd__buf_4
X_2643_ _0760_ _0981_ _1446_ _1454_ VGND VGND VPWR VPWR _0334_ sky130_fd_sc_hd__a31o_1
XFILLER_0_2_533 VGND VGND VPWR VPWR sky130_fd_sc_hd__decap_8
X_2574_ _0713_ _1431_ _1429_ _1432_ net169 VGND VGND VPWR VPWR _0287_ sky130_fd_sc_hd__a32o_1
XFILLER_0_10_333 VGND VGND VPWR VPWR sky130_fd_sc_hd__decap_6
XFILLER_0_22_193 VGND VGND VPWR VPWR sky130_fd_sc_hd__decap_3
X_4313_ clknet_leaf_23_clock _0127_ VGND VGND VPWR VPWR fifo2.mem\[1\]\[4\] sky130_fd_sc_hd__dfxtp_1
XFILLER_0_10_388 VGND VGND VPWR VPWR sky130_fd_sc_hd__decap_8
X_4244_ clknet_leaf_56_clock _0058_ VGND VGND VPWR VPWR fifo3.mem\[8\]\[5\] sky130_fd_sc_hd__dfxtp_1
X_4175_ regis.header_byte\[7\] _0993_ _1040_ net8 VGND VGND VPWR VPWR _1056_ sky130_fd_sc_hd__a22o_1
X_3126_ _1788_ VGND VGND VPWR VPWR _1789_ sky130_fd_sc_hd__clkbuf_4
XFILLER_0_89_182 VPWR VGND VPWR VGND sky130_ef_sc_hd__decap_12
XTAP_1009 VGND VPWR sky130_fd_sc_hd__tapvpwrvgnd_1
X_3057_ net347 _1749_ _1751_ _0932_ VGND VGND VPWR VPWR _0451_ sky130_fd_sc_hd__a22o_1
XFILLER_0_18_433 VPWR VGND VPWR VGND sky130_ef_sc_hd__decap_12
X_3959_ _0799_ _0894_ _0898_ VGND VGND VPWR VPWR _0096_ sky130_fd_sc_hd__a21oi_1
XFILLER_0_18_477 VGND VGND VPWR VPWR sky130_fd_sc_hd__decap_3
XFILLER_0_5_393 VPWR VGND VPWR VGND sky130_ef_sc_hd__decap_12
XPHY_50 VGND VGND VPWR VPWR sky130_fd_sc_hd__decap_3
XPHY_61 VGND VGND VPWR VPWR sky130_fd_sc_hd__decap_3
XPHY_72 VGND VGND VPWR VPWR sky130_fd_sc_hd__decap_3
XPHY_83 VGND VGND VPWR VPWR sky130_fd_sc_hd__decap_3
XFILLER_0_56_517 VGND VGND VPWR VPWR sky130_fd_sc_hd__decap_3
XPHY_94 VGND VGND VPWR VPWR sky130_fd_sc_hd__decap_3
XFILLER_0_91_380 VPWR VGND VPWR VGND sky130_ef_sc_hd__decap_12
XFILLER_0_36_274 VPWR VGND VPWR VGND sky130_ef_sc_hd__decap_12
XFILLER_0_24_447 VPWR VGND VPWR VGND sky130_ef_sc_hd__decap_12
X_2290_ _1177_ VGND VGND VPWR VPWR _1178_ sky130_fd_sc_hd__clkbuf_4
XFILLER_0_47_57 VGND VGND VPWR VPWR sky130_fd_sc_hd__decap_6
XFILLER_0_2_15 VPWR VGND VPWR VGND sky130_ef_sc_hd__decap_12
X_3813_ _0806_ VGND VGND VPWR VPWR _0053_ sky130_fd_sc_hd__clkbuf_1
X_4793_ clknet_leaf_49_clock _0599_ VGND VGND VPWR VPWR fifo3.mem\[13\]\[3\] sky130_fd_sc_hd__dfxtp_1
XFILLER_0_6_124 VGND VGND VPWR VPWR sky130_fd_sc_hd__decap_6
XFILLER_0_27_263 VGND VGND VPWR VPWR sky130_fd_sc_hd__decap_4
XFILLER_0_15_425 VGND VGND VPWR VPWR sky130_fd_sc_hd__decap_6
X_3744_ fifo1.soft_reset _0652_ VGND VGND VPWR VPWR _0756_ sky130_fd_sc_hd__nand2b_2
X_3675_ syn.count0\[3\] syn.count0\[2\] _0699_ _0700_ VGND VGND VPWR VPWR _0701_ sky130_fd_sc_hd__a31o_1
XFILLER_0_12_93 VGND VGND VPWR VPWR sky130_fd_sc_hd__decap_3
XFILLER_0_88_53 VPWR VGND VPWR VGND sky130_ef_sc_hd__decap_12
X_2626_ net330 _1437_ _1442_ _1444_ _0738_ VGND VGND VPWR VPWR _0327_ sky130_fd_sc_hd__a32o_1
XFILLER_0_88_97 VPWR VGND VPWR VGND sky130_ef_sc_hd__decap_12
XFILLER_0_10_141 VGND VGND VPWR VPWR sky130_fd_sc_hd__fill_2
X_2557_ _1424_ VGND VGND VPWR VPWR _1425_ sky130_fd_sc_hd__clkbuf_4
XFILLER_0_56_3 VGND VGND VPWR VPWR sky130_fd_sc_hd__decap_8
X_2488_ fifo1.mem\[0\]\[7\] fifo1.mem\[1\]\[7\] fifo1.mem\[2\]\[7\] fifo1.mem\[3\]\[7\]
+ _1296_ _1339_ VGND VGND VPWR VPWR _1371_ sky130_fd_sc_hd__mux4_1
X_4227_ clknet_leaf_11_clock _0041_ VGND VGND VPWR VPWR fifo1.mem\[0\]\[6\] sky130_fd_sc_hd__dfxtp_1
X_4158_ _1044_ regis.internal_parity\[1\] _1042_ VGND VGND VPWR VPWR _1045_ sky130_fd_sc_hd__a21boi_1
X_3109_ _0927_ _1771_ _1778_ VGND VGND VPWR VPWR _0476_ sky130_fd_sc_hd__a21o_1
X_4089_ _0993_ fifo1.data_in\[0\] VGND VGND VPWR VPWR _0994_ sky130_fd_sc_hd__or2b_1
XFILLER_0_65_303 VGND VGND VPWR VPWR sky130_fd_sc_hd__decap_8
XFILLER_0_33_200 VGND VGND VPWR VPWR sky130_fd_sc_hd__fill_2
XFILLER_0_73_391 VGND VGND VPWR VPWR sky130_fd_sc_hd__fill_1
XFILLER_0_17_38 VGND VGND VPWR VPWR sky130_fd_sc_hd__decap_4
XFILLER_0_33_15 VPWR VGND VPWR VGND sky130_ef_sc_hd__decap_12
XFILLER_0_68_130 VGND VGND VPWR VPWR sky130_fd_sc_hd__decap_3
XFILLER_0_29_517 VPWR VGND VPWR VGND sky130_ef_sc_hd__decap_12
XFILLER_0_83_188 VPWR VGND VPWR VGND sky130_ef_sc_hd__decap_12
Xinput13 resetn VGND VGND VPWR VPWR net13 sky130_fd_sc_hd__buf_2
XFILLER_0_24_266 VGND VGND VPWR VPWR sky130_fd_sc_hd__decap_3
X_3460_ _2019_ _2057_ _2060_ VGND VGND VPWR VPWR _2061_ sky130_fd_sc_hd__nand3_1
X_2411_ _1188_ VGND VGND VPWR VPWR _1296_ sky130_fd_sc_hd__clkbuf_4
X_3391_ _1624_ _1626_ _0996_ _1628_ VGND VGND VPWR VPWR _0534_ sky130_fd_sc_hd__o211a_1
X_2342_ fifo1.count\[0\] _1173_ fifo1.count\[1\] VGND VGND VPWR VPWR _1229_ sky130_fd_sc_hd__o21ai_1
XFILLER_0_42_9 VPWR VGND VPWR VGND sky130_ef_sc_hd__decap_12
X_4012_ fifo3.mem\[6\]\[0\] _0944_ _0943_ VGND VGND VPWR VPWR _0945_ sky130_fd_sc_hd__a21bo_1
X_2273_ fifo1.rd_pointer\[1\] _1155_ _1160_ fifo1.rd_pointer\[2\] VGND VGND VPWR VPWR
+ _1164_ sky130_fd_sc_hd__a31o_1
XFILLER_0_79_417 VGND VGND VPWR VPWR sky130_fd_sc_hd__decap_4
XFILLER_0_90_21 VGND VGND VPWR VPWR sky130_fd_sc_hd__decap_6
XFILLER_0_90_65 VPWR VGND VPWR VGND sky130_ef_sc_hd__decap_12
XFILLER_0_47_325 VGND VGND VPWR VPWR sky130_fd_sc_hd__decap_8
X_4776_ clknet_leaf_58_clock _0582_ VGND VGND VPWR VPWR fifo3.mem\[11\]\[4\] sky130_fd_sc_hd__dfxtp_1
XFILLER_0_15_233 VGND VGND VPWR VPWR sky130_fd_sc_hd__decap_3
XFILLER_0_7_477 VGND VGND VPWR VPWR sky130_fd_sc_hd__fill_1
X_3727_ fifo1.data_in\[6\] VGND VGND VPWR VPWR _0742_ sky130_fd_sc_hd__clkbuf_8
X_3658_ fsm1.full_state _0654_ _0648_ VGND VGND VPWR VPWR _0689_ sky130_fd_sc_hd__and3_1
X_3589_ fifo2.rd_pointer\[4\] fifo2.wr_pointer\[4\] VGND VGND VPWR VPWR _0627_ sky130_fd_sc_hd__xor2_4
X_2609_ _0972_ _0957_ _0716_ _0958_ _0729_ VGND VGND VPWR VPWR _1441_ sky130_fd_sc_hd__o41a_4
XFILLER_0_85_409 VGND VGND VPWR VPWR sky130_fd_sc_hd__fill_1
XFILLER_0_78_450 VGND VGND VPWR VPWR sky130_fd_sc_hd__fill_2
XFILLER_0_53_317 VGND VGND VPWR VPWR sky130_fd_sc_hd__decap_8
XFILLER_0_21_225 VGND VGND VPWR VPWR sky130_fd_sc_hd__decap_8
XTAP_409 VGND VPWR sky130_fd_sc_hd__tapvpwrvgnd_1
XFILLER_0_28_15 VPWR VGND VPWR VGND sky130_ef_sc_hd__decap_12
XFILLER_0_44_58 VGND VGND VPWR VPWR sky130_fd_sc_hd__decap_8
XFILLER_0_29_303 VGND VGND VPWR VPWR sky130_fd_sc_hd__decap_8
X_2960_ _1620_ fifo2.count\[3\] _1508_ VGND VGND VPWR VPWR _1663_ sky130_fd_sc_hd__or3_1
XFILLER_0_56_100 VGND VGND VPWR VPWR sky130_fd_sc_hd__fill_2
XFILLER_0_69_494 VGND VGND VPWR VPWR sky130_fd_sc_hd__decap_8
XFILLER_0_44_306 VGND VGND VPWR VPWR sky130_fd_sc_hd__fill_2
X_2891_ _1550_ fifo2.mem\[4\]\[3\] _1570_ VGND VGND VPWR VPWR _1596_ sky130_fd_sc_hd__o21bai_1
X_4630_ clknet_leaf_60_clock _0436_ VGND VGND VPWR VPWR net19 sky130_fd_sc_hd__dfxtp_1
XFILLER_0_4_425 VGND VGND VPWR VPWR sky130_fd_sc_hd__fill_1
XFILLER_0_37_391 VGND VGND VPWR VPWR sky130_fd_sc_hd__fill_1
X_4561_ clknet_leaf_27_clock _0367_ VGND VGND VPWR VPWR fifo2.mem\[2\]\[8\] sky130_fd_sc_hd__dfxtp_1
XFILLER_0_71_169 VGND VGND VPWR VPWR sky130_fd_sc_hd__decap_4
XFILLER_0_40_501 VPWR VGND VPWR VGND sky130_ef_sc_hd__decap_12
XFILLER_0_12_225 VGND VGND VPWR VPWR sky130_fd_sc_hd__decap_6
X_3512_ _1759_ _0833_ _1773_ _0694_ _0799_ VGND VGND VPWR VPWR _2087_ sky130_fd_sc_hd__o311a_1
X_4492_ clknet_leaf_38_clock _0298_ VGND VGND VPWR VPWR fifo2.mem\[12\]\[2\] sky130_fd_sc_hd__dfxtp_1
XFILLER_0_69_55 VGND VGND VPWR VPWR sky130_fd_sc_hd__fill_1
XFILLER_0_12_269 VGND VGND VPWR VPWR sky130_fd_sc_hd__fill_1
X_3443_ _1904_ _1915_ _1941_ _2045_ VGND VGND VPWR VPWR _2046_ sky130_fd_sc_hd__nand4_2
XTAP_910 VGND VPWR sky130_fd_sc_hd__tapvpwrvgnd_1
XTAP_943 VGND VPWR sky130_fd_sc_hd__tapvpwrvgnd_1
XTAP_932 VGND VPWR sky130_fd_sc_hd__tapvpwrvgnd_1
XTAP_921 VGND VPWR sky130_fd_sc_hd__tapvpwrvgnd_1
X_3374_ net332 _1413_ _1988_ VGND VGND VPWR VPWR _0531_ sky130_fd_sc_hd__a21oi_1
XFILLER_0_85_65 VGND VGND VPWR VPWR sky130_fd_sc_hd__decap_4
XTAP_987 VGND VPWR sky130_fd_sc_hd__tapvpwrvgnd_1
XTAP_976 VGND VPWR sky130_fd_sc_hd__tapvpwrvgnd_1
XTAP_965 VGND VPWR sky130_fd_sc_hd__tapvpwrvgnd_1
XTAP_954 VGND VPWR sky130_fd_sc_hd__tapvpwrvgnd_1
X_2325_ _1210_ _1212_ _0002_ VGND VGND VPWR VPWR _1213_ sky130_fd_sc_hd__a21o_1
XTAP_998 VGND VPWR sky130_fd_sc_hd__tapvpwrvgnd_1
X_2256_ _0613_ fifo1.wr_pointer\[2\] VGND VGND VPWR VPWR _1150_ sky130_fd_sc_hd__and2_1
XFILLER_0_79_214 VGND VGND VPWR VPWR sky130_fd_sc_hd__decap_8
XFILLER_0_79_258 VGND VGND VPWR VPWR sky130_fd_sc_hd__decap_3
XFILLER_0_19_3 VPWR VGND VPWR VGND sky130_ef_sc_hd__decap_12
X_2187_ _1104_ _1117_ _1118_ net263 VGND VGND VPWR VPWR _0214_ sky130_fd_sc_hd__a22o_1
XFILLER_0_67_409 VPWR VGND VPWR VGND sky130_ef_sc_hd__decap_12
XFILLER_0_47_133 VGND VGND VPWR VPWR sky130_fd_sc_hd__fill_1
XFILLER_0_90_412 VGND VGND VPWR VPWR sky130_fd_sc_hd__fill_2
XFILLER_0_90_401 VGND VGND VPWR VPWR sky130_fd_sc_hd__decap_8
XFILLER_0_35_328 VGND VGND VPWR VPWR sky130_fd_sc_hd__decap_8
XFILLER_0_7_263 VGND VGND VPWR VPWR sky130_fd_sc_hd__fill_1
XFILLER_0_90_489 VPWR VGND VPWR VGND sky130_ef_sc_hd__decap_12
X_4759_ clknet_leaf_40_clock _0565_ VGND VGND VPWR VPWR fifo2.mem\[11\]\[5\] sky130_fd_sc_hd__dfxtp_1
XFILLER_0_43_361 VGND VGND VPWR VPWR sky130_fd_sc_hd__decap_3
XFILLER_0_50_309 VGND VGND VPWR VPWR sky130_fd_sc_hd__decap_3
XFILLER_0_11_291 VPWR VGND VPWR VGND sky130_ef_sc_hd__decap_12
XFILLER_0_38_133 VGND VGND VPWR VPWR sky130_fd_sc_hd__decap_6
XFILLER_0_66_453 VGND VGND VPWR VPWR sky130_fd_sc_hd__fill_1
XFILLER_0_26_306 VGND VGND VPWR VPWR sky130_fd_sc_hd__fill_2
XFILLER_0_30_27 VGND VGND VPWR VPWR sky130_fd_sc_hd__fill_1
XFILLER_0_1_417 VPWR VGND VPWR VGND sky130_ef_sc_hd__decap_12
XFILLER_0_61_191 VGND VGND VPWR VPWR sky130_fd_sc_hd__decap_4
XTAP_206 VGND VPWR sky130_fd_sc_hd__tapvpwrvgnd_1
XFILLER_0_39_47 VGND VGND VPWR VPWR sky130_fd_sc_hd__fill_2
XTAP_239 VGND VPWR sky130_fd_sc_hd__tapvpwrvgnd_1
XTAP_217 VGND VPWR sky130_fd_sc_hd__tapvpwrvgnd_1
XTAP_228 VGND VPWR sky130_fd_sc_hd__tapvpwrvgnd_1
X_2110_ regis.internal_parity\[1\] _1078_ _1069_ _1079_ _1080_ VGND VGND VPWR VPWR
+ _1081_ sky130_fd_sc_hd__o2111a_1
Xhold2 fifo2.mem\[14\]\[6\] VGND VGND VPWR VPWR net50 sky130_fd_sc_hd__dlygate4sd3_1
X_3090_ _1759_ _1419_ _0835_ _0782_ fifo3.mem\[2\]\[5\] VGND VGND VPWR VPWR _1766_
+ sky130_fd_sc_hd__o311a_1
XFILLER_0_76_239 VPWR VGND VPWR VGND sky130_ef_sc_hd__decap_12
XFILLER_0_9_517 VPWR VGND VPWR VGND sky130_ef_sc_hd__decap_12
X_3992_ _0928_ _0786_ fifo3.mem\[5\]\[3\] VGND VGND VPWR VPWR _0931_ sky130_fd_sc_hd__and3_1
XFILLER_0_91_209 VPWR VGND VPWR VGND sky130_ef_sc_hd__decap_12
X_2943_ fifo2.mem\[3\]\[4\] _1582_ _1646_ VGND VGND VPWR VPWR _1647_ sky130_fd_sc_hd__o21ai_1
XFILLER_0_71_78 VGND VGND VPWR VPWR sky130_fd_sc_hd__decap_6
XFILLER_0_29_166 VGND VGND VPWR VPWR sky130_fd_sc_hd__fill_2
X_2874_ _1576_ _1577_ _1578_ _1579_ VGND VGND VPWR VPWR _1580_ sky130_fd_sc_hd__a22oi_4
X_4613_ clknet_leaf_6_clock _0419_ VGND VGND VPWR VPWR fifo1.mem\[4\]\[6\] sky130_fd_sc_hd__dfxtp_1
X_4544_ clknet_leaf_15_clock _0350_ VGND VGND VPWR VPWR fifo1.mem\[13\]\[0\] sky130_fd_sc_hd__dfxtp_1
XFILLER_0_40_397 VGND VGND VPWR VPWR sky130_fd_sc_hd__fill_2
X_4475_ clknet_leaf_36_clock _0281_ VGND VGND VPWR VPWR fifo2.mem\[14\]\[3\] sky130_fd_sc_hd__dfxtp_1
X_3426_ _2023_ _2029_ _2025_ _2030_ VGND VGND VPWR VPWR _2031_ sky130_fd_sc_hd__a211o_1
X_3357_ _0828_ _1420_ _1979_ _0823_ _0783_ VGND VGND VPWR VPWR _0523_ sky130_fd_sc_hd__o221a_1
XTAP_740 VGND VPWR sky130_fd_sc_hd__tapvpwrvgnd_1
XTAP_751 VGND VPWR sky130_fd_sc_hd__tapvpwrvgnd_1
X_2308_ _1173_ fifo1.count\[0\] VGND VGND VPWR VPWR _1196_ sky130_fd_sc_hd__and2_1
XTAP_762 VGND VPWR sky130_fd_sc_hd__tapvpwrvgnd_1
XTAP_773 VGND VPWR sky130_fd_sc_hd__tapvpwrvgnd_1
XTAP_784 VGND VPWR sky130_fd_sc_hd__tapvpwrvgnd_1
XTAP_795 VGND VPWR sky130_fd_sc_hd__tapvpwrvgnd_1
X_3288_ _1904_ _1915_ _1169_ VGND VGND VPWR VPWR _1916_ sky130_fd_sc_hd__and3_1
X_2239_ _1098_ _1141_ _1144_ net108 VGND VGND VPWR VPWR _0240_ sky130_fd_sc_hd__a22o_1
Xclkbuf_leaf_32_clock clknet_3_7__leaf_clock VGND VGND VPWR VPWR clknet_leaf_32_clock
+ sky130_fd_sc_hd__clkbuf_16
XFILLER_0_67_206 VGND VGND VPWR VPWR sky130_fd_sc_hd__fill_2
XFILLER_0_48_453 VGND VGND VPWR VPWR sky130_fd_sc_hd__fill_1
Xclkbuf_leaf_47_clock clknet_3_4__leaf_clock VGND VGND VPWR VPWR clknet_leaf_47_clock
+ sky130_fd_sc_hd__clkbuf_16
XFILLER_0_0_81 VGND VGND VPWR VPWR sky130_fd_sc_hd__decap_3
XFILLER_0_48_475 VGND VGND VPWR VPWR sky130_fd_sc_hd__fill_1
XFILLER_0_35_125 VGND VGND VPWR VPWR sky130_fd_sc_hd__decap_6
XFILLER_0_63_456 VGND VGND VPWR VPWR sky130_fd_sc_hd__decap_6
XFILLER_0_90_253 VPWR VGND VPWR VGND sky130_ef_sc_hd__decap_12
XFILLER_0_50_128 VGND VGND VPWR VPWR sky130_fd_sc_hd__decap_4
XFILLER_0_31_386 VGND VGND VPWR VPWR sky130_fd_sc_hd__decap_6
XFILLER_0_8_3 VPWR VGND VPWR VGND sky130_ef_sc_hd__decap_12
XFILLER_0_39_442 VGND VGND VPWR VPWR sky130_fd_sc_hd__decap_6
XFILLER_0_39_453 VGND VGND VPWR VPWR sky130_fd_sc_hd__fill_1
XFILLER_0_41_15 VPWR VGND VPWR VGND sky130_ef_sc_hd__decap_12
XFILLER_0_81_231 VGND VGND VPWR VPWR sky130_fd_sc_hd__fill_1
XFILLER_0_26_114 VGND VGND VPWR VPWR sky130_fd_sc_hd__decap_8
XFILLER_0_81_275 VGND VGND VPWR VPWR sky130_fd_sc_hd__decap_4
XFILLER_0_54_489 VGND VGND VPWR VPWR sky130_fd_sc_hd__fill_2
XFILLER_0_1_225 VPWR VGND VPWR VGND sky130_ef_sc_hd__decap_12
X_2590_ _0740_ _0869_ _1428_ _1434_ net131 VGND VGND VPWR VPWR _0301_ sky130_fd_sc_hd__a32o_1
XFILLER_0_1_258 VGND VGND VPWR VPWR sky130_fd_sc_hd__decap_4
XFILLER_0_22_386 VGND VGND VPWR VPWR sky130_fd_sc_hd__decap_6
X_4260_ clknet_leaf_41_clock _0074_ VGND VGND VPWR VPWR fifo2.mem\[8\]\[3\] sky130_fd_sc_hd__dfxtp_1
X_4191_ regis.packet_parity\[5\] _0682_ VGND VGND VPWR VPWR _1066_ sky130_fd_sc_hd__or2_1
X_3211_ _0009_ VGND VGND VPWR VPWR _1841_ sky130_fd_sc_hd__clkbuf_4
X_3142_ _0938_ _1789_ _1797_ VGND VGND VPWR VPWR _0490_ sky130_fd_sc_hd__o21a_1
XFILLER_0_82_11 VGND VGND VPWR VPWR sky130_fd_sc_hd__fill_1
X_3073_ _0740_ _1754_ _1756_ _1757_ net239 VGND VGND VPWR VPWR _0461_ sky130_fd_sc_hd__a32o_1
X_3975_ net8 regis.fifo_full_state\[7\] _0910_ VGND VGND VPWR VPWR _0918_ sky130_fd_sc_hd__mux2_1
XFILLER_0_17_125 VPWR VGND VPWR VGND sky130_ef_sc_hd__decap_12
X_2926_ _1601_ _1603_ _1623_ VGND VGND VPWR VPWR _1630_ sky130_fd_sc_hd__a21oi_1
XFILLER_0_17_169 VGND VGND VPWR VPWR sky130_fd_sc_hd__decap_6
X_2857_ _1550_ fifo2.mem\[6\]\[2\] _1562_ VGND VGND VPWR VPWR _1563_ sky130_fd_sc_hd__o21ai_1
XFILLER_0_86_3 VPWR VGND VPWR VGND sky130_ef_sc_hd__decap_12
XFILLER_0_72_297 VGND VGND VPWR VPWR sky130_fd_sc_hd__decap_3
Xhold210 fifo3.mem\[0\]\[6\] VGND VGND VPWR VPWR net258 sky130_fd_sc_hd__dlygate4sd3_1
X_2788_ fifo2.count\[6\] fifo2.count\[5\] _1501_ _1502_ VGND VGND VPWR VPWR _1506_
+ sky130_fd_sc_hd__and4bb_1
Xhold243 fifo2.mem\[4\]\[0\] VGND VGND VPWR VPWR net291 sky130_fd_sc_hd__dlygate4sd3_1
X_4527_ clknet_leaf_23_clock _0333_ VGND VGND VPWR VPWR fifo2.mem\[7\]\[1\] sky130_fd_sc_hd__dfxtp_1
Xhold221 fifo2.mem\[14\]\[0\] VGND VGND VPWR VPWR net269 sky130_fd_sc_hd__dlygate4sd3_1
XFILLER_0_40_172 VGND VGND VPWR VPWR sky130_fd_sc_hd__decap_3
Xhold232 fifo1.mem\[9\]\[7\] VGND VGND VPWR VPWR net280 sky130_fd_sc_hd__dlygate4sd3_1
Xhold254 fifo1.mem\[1\]\[5\] VGND VGND VPWR VPWR net302 sky130_fd_sc_hd__dlygate4sd3_1
X_4458_ clknet_leaf_17_clock _0264_ VGND VGND VPWR VPWR fifo1.count\[6\] sky130_fd_sc_hd__dfxtp_1
Xhold287 fifo2.mem\[4\]\[7\] VGND VGND VPWR VPWR net335 sky130_fd_sc_hd__dlygate4sd3_1
Xhold265 fifo3.mem\[0\]\[3\] VGND VGND VPWR VPWR net313 sky130_fd_sc_hd__dlygate4sd3_1
Xhold276 fifo2.mem\[5\]\[8\] VGND VGND VPWR VPWR net324 sky130_fd_sc_hd__dlygate4sd3_1
X_3409_ _1846_ fifo3.mem\[2\]\[8\] _1857_ VGND VGND VPWR VPWR _2015_ sky130_fd_sc_hd__o21a_1
Xhold298 fifo2.mem\[5\]\[2\] VGND VGND VPWR VPWR net346 sky130_fd_sc_hd__dlygate4sd3_1
X_4389_ clknet_leaf_12_clock _0203_ VGND VGND VPWR VPWR fifo1.mem\[2\]\[0\] sky130_fd_sc_hd__dfxtp_1
XTAP_570 VGND VPWR sky130_fd_sc_hd__tapvpwrvgnd_1
XTAP_581 VGND VPWR sky130_fd_sc_hd__tapvpwrvgnd_1
XTAP_592 VGND VPWR sky130_fd_sc_hd__tapvpwrvgnd_1
XFILLER_0_83_529 VPWR VGND VPWR VGND sky130_ef_sc_hd__decap_12
XFILLER_0_36_456 VGND VGND VPWR VPWR sky130_fd_sc_hd__fill_2
XFILLER_0_36_15 VPWR VGND VPWR VGND sky130_ef_sc_hd__decap_12
XFILLER_0_86_389 VPWR VGND VPWR VGND sky130_ef_sc_hd__decap_12
XFILLER_0_74_529 VGND VGND VPWR VPWR sky130_fd_sc_hd__decap_3
XFILLER_0_27_423 VGND VGND VPWR VPWR sky130_fd_sc_hd__decap_4
XFILLER_0_27_434 VGND VGND VPWR VPWR sky130_fd_sc_hd__fill_1
X_3760_ fifo1.data_in\[7\] VGND VGND VPWR VPWR _0765_ sky130_fd_sc_hd__buf_4
X_2711_ net324 _1478_ _1480_ _0939_ VGND VGND VPWR VPWR _0376_ sky130_fd_sc_hd__a22o_1
X_3691_ fifo1.data_in\[0\] VGND VGND VPWR VPWR _0712_ sky130_fd_sc_hd__buf_4
XFILLER_0_54_275 VGND VGND VPWR VPWR sky130_fd_sc_hd__decap_8
X_2642_ _1447_ _1448_ _1450_ _1451_ fifo2.mem\[7\]\[2\] VGND VGND VPWR VPWR _1454_
+ sky130_fd_sc_hd__o311a_1
XFILLER_0_2_501 VPWR VGND VPWR VGND sky130_ef_sc_hd__decap_12
X_2573_ _0955_ _1427_ _0974_ VGND VGND VPWR VPWR _1432_ sky130_fd_sc_hd__a21oi_4
X_4312_ clknet_leaf_23_clock _0126_ VGND VGND VPWR VPWR fifo2.mem\[1\]\[3\] sky130_fd_sc_hd__dfxtp_1
X_4243_ clknet_leaf_57_clock _0057_ VGND VGND VPWR VPWR fifo3.mem\[8\]\[4\] sky130_fd_sc_hd__dfxtp_1
X_4174_ regis.internal_parity\[6\] _1054_ _1055_ VGND VGND VPWR VPWR _0165_ sky130_fd_sc_hd__o21a_1
X_3125_ _0769_ _0776_ _0780_ _0802_ VGND VGND VPWR VPWR _1788_ sky130_fd_sc_hd__nand4_4
X_3056_ net334 _1749_ _1751_ _0930_ VGND VGND VPWR VPWR _0450_ sky130_fd_sc_hd__a22o_1
XFILLER_0_89_194 VPWR VGND VPWR VGND sky130_ef_sc_hd__decap_12
XFILLER_0_77_334 VGND VGND VPWR VPWR sky130_fd_sc_hd__fill_2
XFILLER_0_77_378 VGND VGND VPWR VPWR sky130_fd_sc_hd__fill_1
XFILLER_0_9_111 VGND VGND VPWR VPWR sky130_fd_sc_hd__fill_1
XFILLER_0_9_166 VGND VGND VPWR VPWR sky130_fd_sc_hd__fill_2
XFILLER_0_18_445 VPWR VGND VPWR VGND sky130_ef_sc_hd__decap_12
XFILLER_0_9_199 VPWR VGND VPWR VGND sky130_ef_sc_hd__decap_12
X_3958_ _0908_ _0909_ _0898_ VGND VGND VPWR VPWR _0095_ sky130_fd_sc_hd__a21boi_1
XFILLER_0_45_231 VPWR VGND VPWR VGND sky130_ef_sc_hd__decap_12
X_3889_ _0725_ _0859_ fifo1.data_in\[2\] _0860_ VGND VGND VPWR VPWR _0863_ sky130_fd_sc_hd__and4b_1
XFILLER_0_33_426 VGND VGND VPWR VPWR sky130_fd_sc_hd__fill_1
X_2909_ fifo2.mem\[11\]\[3\] _1582_ _1613_ VGND VGND VPWR VPWR _1614_ sky130_fd_sc_hd__o21ai_1
XPHY_40 VGND VGND VPWR VPWR sky130_fd_sc_hd__decap_3
XFILLER_0_68_345 VGND VGND VPWR VPWR sky130_fd_sc_hd__fill_1
XPHY_51 VGND VGND VPWR VPWR sky130_fd_sc_hd__decap_3
XPHY_62 VGND VGND VPWR VPWR sky130_fd_sc_hd__decap_3
XPHY_73 VGND VGND VPWR VPWR sky130_fd_sc_hd__decap_3
XFILLER_0_83_337 VPWR VGND VPWR VGND sky130_ef_sc_hd__decap_12
XPHY_84 VGND VGND VPWR VPWR sky130_fd_sc_hd__decap_3
XPHY_95 VGND VGND VPWR VPWR sky130_fd_sc_hd__decap_3
XFILLER_0_36_253 VGND VGND VPWR VPWR sky130_fd_sc_hd__fill_2
XFILLER_0_36_286 VPWR VGND VPWR VGND sky130_ef_sc_hd__decap_12
XFILLER_0_24_459 VGND VGND VPWR VPWR sky130_fd_sc_hd__decap_3
XFILLER_0_51_223 VGND VGND VPWR VPWR sky130_fd_sc_hd__fill_1
XFILLER_0_2_27 VGND VGND VPWR VPWR sky130_fd_sc_hd__fill_1
XFILLER_0_59_312 VGND VGND VPWR VPWR sky130_fd_sc_hd__decap_8
XFILLER_0_63_57 VGND VGND VPWR VPWR sky130_fd_sc_hd__decap_4
XFILLER_0_59_334 VGND VGND VPWR VPWR sky130_fd_sc_hd__fill_2
XFILLER_0_59_356 VGND VGND VPWR VPWR sky130_fd_sc_hd__fill_1
XFILLER_0_86_153 VGND VGND VPWR VPWR sky130_fd_sc_hd__fill_1
X_3812_ _0801_ _0712_ _0805_ VGND VGND VPWR VPWR _0806_ sky130_fd_sc_hd__mux2_1
XFILLER_0_74_359 VGND VGND VPWR VPWR sky130_fd_sc_hd__decap_4
X_4792_ clknet_leaf_56_clock _0598_ VGND VGND VPWR VPWR fifo3.mem\[13\]\[2\] sky130_fd_sc_hd__dfxtp_1
XFILLER_0_82_381 VGND VGND VPWR VPWR sky130_fd_sc_hd__fill_1
X_3743_ _0754_ VGND VGND VPWR VPWR _0755_ sky130_fd_sc_hd__clkbuf_4
X_3674_ net40 _0652_ _0696_ VGND VGND VPWR VPWR _0700_ sky130_fd_sc_hd__nand3_1
XFILLER_0_42_245 VGND VGND VPWR VPWR sky130_fd_sc_hd__decap_3
XFILLER_0_42_278 VGND VGND VPWR VPWR sky130_fd_sc_hd__fill_2
X_2625_ net294 _1437_ _1442_ _1444_ _0736_ VGND VGND VPWR VPWR _0326_ sky130_fd_sc_hd__a32o_1
XFILLER_0_88_65 VPWR VGND VPWR VGND sky130_ef_sc_hd__decap_12
X_2556_ fifo2.wr_pointer\[0\] _0726_ VGND VGND VPWR VPWR _1424_ sky130_fd_sc_hd__and2b_1
X_2487_ _1335_ _1341_ _1346_ _1348_ VGND VGND VPWR VPWR _1370_ sky130_fd_sc_hd__o22a_1
X_4226_ clknet_leaf_13_clock _0040_ VGND VGND VPWR VPWR fifo1.mem\[0\]\[5\] sky130_fd_sc_hd__dfxtp_1
XFILLER_0_10_197 VGND VGND VPWR VPWR sky130_fd_sc_hd__decap_8
XFILLER_0_49_3 VGND VGND VPWR VPWR sky130_fd_sc_hd__fill_1
X_4157_ regis.header_byte\[1\] _0993_ _1040_ _0658_ VGND VGND VPWR VPWR _1044_ sky130_fd_sc_hd__a22o_1
X_3108_ _0839_ _1772_ _1774_ fifo3.mem\[9\]\[2\] _1775_ VGND VGND VPWR VPWR _1778_
+ sky130_fd_sc_hd__o311a_1
X_4088_ fifo1.lfd_state VGND VGND VPWR VPWR _0993_ sky130_fd_sc_hd__clkbuf_4
XFILLER_0_77_120 VGND VGND VPWR VPWR sky130_fd_sc_hd__fill_1
X_3039_ fifo2.count\[4\] fifo2.count\[3\] _1620_ fifo2.count\[5\] VGND VGND VPWR VPWR
+ _1740_ sky130_fd_sc_hd__o31ai_1
XFILLER_0_77_164 VGND VGND VPWR VPWR sky130_fd_sc_hd__decap_4
XFILLER_0_77_153 VGND VGND VPWR VPWR sky130_fd_sc_hd__decap_3
XFILLER_0_14_481 VGND VGND VPWR VPWR sky130_fd_sc_hd__fill_1
XFILLER_0_29_529 VPWR VGND VPWR VGND sky130_ef_sc_hd__decap_12
XFILLER_0_33_27 VGND VGND VPWR VPWR sky130_fd_sc_hd__decap_8
XFILLER_0_68_197 VGND VGND VPWR VPWR sky130_fd_sc_hd__fill_1
XFILLER_0_37_540 VGND VGND VPWR VPWR sky130_fd_sc_hd__fill_1
X_2410_ _1221_ VGND VGND VPWR VPWR _1295_ sky130_fd_sc_hd__clkbuf_4
X_3390_ _1625_ _1998_ _0996_ _2002_ VGND VGND VPWR VPWR _0533_ sky130_fd_sc_hd__o211a_1
X_2341_ _1174_ _1195_ _1196_ _1228_ _1121_ VGND VGND VPWR VPWR _0258_ sky130_fd_sc_hd__o311a_1
XFILLER_0_20_462 VGND VGND VPWR VPWR sky130_fd_sc_hd__decap_6
X_2272_ fifo1.rd_pointer\[1\] _1155_ _1160_ _1163_ VGND VGND VPWR VPWR _0254_ sky130_fd_sc_hd__a31oi_1
X_4011_ _0789_ VGND VGND VPWR VPWR _0944_ sky130_fd_sc_hd__clkbuf_4
XFILLER_0_87_473 VPWR VGND VPWR VGND sky130_ef_sc_hd__decap_12
XFILLER_0_90_77 VGND VGND VPWR VPWR sky130_fd_sc_hd__decap_6
X_4775_ clknet_leaf_58_clock _0581_ VGND VGND VPWR VPWR fifo3.mem\[11\]\[3\] sky130_fd_sc_hd__dfxtp_1
XFILLER_0_43_521 VPWR VGND VPWR VGND sky130_ef_sc_hd__decap_12
X_3726_ _0740_ _0715_ _0741_ _0730_ net188 VGND VGND VPWR VPWR _0031_ sky130_fd_sc_hd__a32o_1
X_3657_ _0687_ _0665_ _0688_ _0673_ VGND VGND VPWR VPWR _0018_ sky130_fd_sc_hd__o22ai_1
XFILLER_0_70_395 VPWR VGND VPWR VGND sky130_ef_sc_hd__decap_12
X_2608_ _1435_ _1437_ fifo2.mem\[10\]\[8\] _1440_ _1426_ VGND VGND VPWR VPWR _0313_
+ sky130_fd_sc_hd__a32o_1
X_3588_ fifo2.rd_pointer\[3\] fifo2.wr_pointer\[3\] VGND VGND VPWR VPWR _0626_ sky130_fd_sc_hd__xnor2_4
X_2539_ _0772_ VGND VGND VPWR VPWR _1416_ sky130_fd_sc_hd__clkbuf_4
X_4209_ clknet_leaf_25_clock _0023_ VGND VGND VPWR VPWR syn.count0\[3\] sky130_fd_sc_hd__dfxtp_1
XFILLER_0_3_81 VGND VGND VPWR VPWR sky130_fd_sc_hd__decap_8
XFILLER_0_78_473 VGND VGND VPWR VPWR sky130_fd_sc_hd__decap_3
XFILLER_0_38_304 VGND VGND VPWR VPWR sky130_fd_sc_hd__decap_4
XFILLER_0_21_204 VGND VGND VPWR VPWR sky130_fd_sc_hd__decap_8
XFILLER_0_61_362 VGND VGND VPWR VPWR sky130_fd_sc_hd__decap_6
XFILLER_0_28_27 VGND VGND VPWR VPWR sky130_fd_sc_hd__fill_1
XFILLER_0_44_15 VPWR VGND VPWR VGND sky130_ef_sc_hd__decap_12
XFILLER_0_29_326 VGND VGND VPWR VPWR sky130_fd_sc_hd__decap_8
XFILLER_0_29_337 VGND VGND VPWR VPWR sky130_fd_sc_hd__decap_4
XFILLER_0_29_348 VGND VGND VPWR VPWR sky130_fd_sc_hd__decap_4
X_2890_ fifo2.mem\[7\]\[3\] _1556_ VGND VGND VPWR VPWR _1595_ sky130_fd_sc_hd__and2b_1
X_4560_ clknet_leaf_27_clock _0366_ VGND VGND VPWR VPWR fifo2.mem\[2\]\[7\] sky130_fd_sc_hd__dfxtp_1
XFILLER_0_8_15 VPWR VGND VPWR VGND sky130_ef_sc_hd__decap_12
XFILLER_0_52_340 VGND VGND VPWR VPWR sky130_fd_sc_hd__fill_1
X_3511_ _0926_ _2084_ _2086_ VGND VGND VPWR VPWR _0570_ sky130_fd_sc_hd__a21o_1
X_4491_ clknet_leaf_40_clock _0297_ VGND VGND VPWR VPWR fifo2.mem\[12\]\[1\] sky130_fd_sc_hd__dfxtp_1
XFILLER_0_40_513 VPWR VGND VPWR VGND sky130_ef_sc_hd__decap_12
X_3442_ _1827_ _1928_ _2044_ _1816_ VGND VGND VPWR VPWR _2045_ sky130_fd_sc_hd__o211ai_2
XTAP_900 VGND VPWR sky130_fd_sc_hd__tapvpwrvgnd_1
X_3373_ fifo3.rd_pointer\[4\] _1413_ _1005_ VGND VGND VPWR VPWR _1988_ sky130_fd_sc_hd__o21ai_1
XTAP_944 VGND VPWR sky130_fd_sc_hd__tapvpwrvgnd_1
XTAP_933 VGND VPWR sky130_fd_sc_hd__tapvpwrvgnd_1
XTAP_922 VGND VPWR sky130_fd_sc_hd__tapvpwrvgnd_1
XTAP_911 VGND VPWR sky130_fd_sc_hd__tapvpwrvgnd_1
X_2324_ fifo1.mem\[3\]\[2\] _1203_ _1211_ VGND VGND VPWR VPWR _1212_ sky130_fd_sc_hd__o21ai_1
XFILLER_0_85_55 VGND VGND VPWR VPWR sky130_fd_sc_hd__fill_1
XTAP_977 VGND VPWR sky130_fd_sc_hd__tapvpwrvgnd_1
XTAP_966 VGND VPWR sky130_fd_sc_hd__tapvpwrvgnd_1
XTAP_955 VGND VPWR sky130_fd_sc_hd__tapvpwrvgnd_1
XTAP_999 VGND VPWR sky130_fd_sc_hd__tapvpwrvgnd_1
XTAP_988 VGND VPWR sky130_fd_sc_hd__tapvpwrvgnd_1
X_2255_ _1126_ _1149_ _0757_ VGND VGND VPWR VPWR _0251_ sky130_fd_sc_hd__a21oi_1
X_2186_ _1098_ _1117_ _1118_ net205 VGND VGND VPWR VPWR _0213_ sky130_fd_sc_hd__a22o_1
XFILLER_0_87_281 VPWR VGND VPWR VGND sky130_ef_sc_hd__decap_12
XFILLER_0_75_454 VGND VGND VPWR VPWR sky130_fd_sc_hd__fill_1
XFILLER_0_62_148 VGND VGND VPWR VPWR sky130_fd_sc_hd__decap_4
X_4758_ clknet_leaf_33_clock _0564_ VGND VGND VPWR VPWR fifo2.mem\[11\]\[4\] sky130_fd_sc_hd__dfxtp_1
X_3709_ _0725_ _0728_ _0722_ _0729_ VGND VGND VPWR VPWR _0730_ sky130_fd_sc_hd__o31a_4
X_4689_ clknet_leaf_32_clock _0495_ VGND VGND VPWR VPWR _0007_ sky130_fd_sc_hd__dfxtp_2
XFILLER_0_11_281 VGND VGND VPWR VPWR sky130_fd_sc_hd__decap_4
XFILLER_0_14_29 VGND VGND VPWR VPWR sky130_fd_sc_hd__decap_4
XFILLER_0_38_145 VGND VGND VPWR VPWR sky130_fd_sc_hd__fill_1
XFILLER_0_66_465 VGND VGND VPWR VPWR sky130_fd_sc_hd__decap_8
XFILLER_0_81_457 VGND VGND VPWR VPWR sky130_fd_sc_hd__decap_3
XFILLER_0_81_468 VPWR VGND VPWR VGND sky130_ef_sc_hd__decap_12
XFILLER_0_34_362 VGND VGND VPWR VPWR sky130_fd_sc_hd__fill_2
XFILLER_0_1_429 VPWR VGND VPWR VGND sky130_ef_sc_hd__decap_12
XFILLER_0_39_15 VPWR VGND VPWR VGND sky130_ef_sc_hd__decap_12
XTAP_207 VGND VPWR sky130_fd_sc_hd__tapvpwrvgnd_1
XTAP_218 VGND VPWR sky130_fd_sc_hd__tapvpwrvgnd_1
XTAP_229 VGND VPWR sky130_fd_sc_hd__tapvpwrvgnd_1
Xhold3 fifo2.mem\[8\]\[8\] VGND VGND VPWR VPWR net51 sky130_fd_sc_hd__dlygate4sd3_1
XFILLER_0_89_502 VGND VGND VPWR VPWR sky130_fd_sc_hd__fill_2
X_3991_ _0735_ VGND VGND VPWR VPWR _0930_ sky130_fd_sc_hd__buf_4
XFILLER_0_69_281 VGND VGND VPWR VPWR sky130_fd_sc_hd__fill_2
XFILLER_0_9_529 VPWR VGND VPWR VGND sky130_ef_sc_hd__decap_12
XFILLER_0_29_145 VGND VGND VPWR VPWR sky130_fd_sc_hd__decap_4
X_2942_ _1567_ fifo2.mem\[2\]\[4\] _1570_ VGND VGND VPWR VPWR _1646_ sky130_fd_sc_hd__o21a_1
XFILLER_0_71_57 VGND VGND VPWR VPWR sky130_fd_sc_hd__decap_4
X_2873_ fifo2.mem\[15\]\[2\] _0004_ VGND VGND VPWR VPWR _1579_ sky130_fd_sc_hd__or2b_1
XFILLER_0_57_498 VGND VGND VPWR VPWR sky130_fd_sc_hd__decap_3
XFILLER_0_25_340 VGND VGND VPWR VPWR sky130_fd_sc_hd__fill_2
X_4612_ clknet_leaf_7_clock _0418_ VGND VGND VPWR VPWR fifo1.mem\[4\]\[5\] sky130_fd_sc_hd__dfxtp_1
X_4543_ clknet_leaf_16_clock _0349_ VGND VGND VPWR VPWR fifo1.mem\[12\]\[8\] sky130_fd_sc_hd__dfxtp_1
X_4474_ clknet_leaf_38_clock _0280_ VGND VGND VPWR VPWR fifo2.mem\[14\]\[2\] sky130_fd_sc_hd__dfxtp_1
X_3425_ _1845_ _1861_ _1891_ _1878_ VGND VGND VPWR VPWR _2030_ sky130_fd_sc_hd__and4_1
X_3356_ _0633_ _0773_ _0774_ _0775_ _0831_ VGND VGND VPWR VPWR _1979_ sky130_fd_sc_hd__o311a_1
XTAP_730 VGND VPWR sky130_fd_sc_hd__tapvpwrvgnd_1
XTAP_741 VGND VPWR sky130_fd_sc_hd__tapvpwrvgnd_1
XTAP_752 VGND VPWR sky130_fd_sc_hd__tapvpwrvgnd_1
X_2307_ _1194_ VGND VGND VPWR VPWR _1195_ sky130_fd_sc_hd__buf_2
X_3287_ _1827_ _1909_ _1914_ _1816_ VGND VGND VPWR VPWR _1915_ sky130_fd_sc_hd__o211ai_4
XTAP_763 VGND VPWR sky130_fd_sc_hd__tapvpwrvgnd_1
XTAP_774 VGND VPWR sky130_fd_sc_hd__tapvpwrvgnd_1
XTAP_785 VGND VPWR sky130_fd_sc_hd__tapvpwrvgnd_1
X_2238_ _1110_ _1141_ _1144_ net85 VGND VGND VPWR VPWR _0239_ sky130_fd_sc_hd__a22o_1
XFILLER_0_31_3 VGND VGND VPWR VPWR sky130_fd_sc_hd__fill_2
XTAP_796 VGND VPWR sky130_fd_sc_hd__tapvpwrvgnd_1
X_2169_ fifo1.wr_pointer\[0\] fifo1.wr_pointer\[1\] VGND VGND VPWR VPWR _1112_ sky130_fd_sc_hd__and2b_1
XFILLER_0_90_221 VPWR VGND VPWR VGND sky130_ef_sc_hd__decap_12
XFILLER_0_90_265 VPWR VGND VPWR VGND sky130_ef_sc_hd__decap_12
XFILLER_0_16_384 VGND VGND VPWR VPWR sky130_fd_sc_hd__fill_1
XFILLER_0_58_218 VPWR VGND VPWR VGND sky130_ef_sc_hd__decap_12
XFILLER_0_41_27 VPWR VGND VPWR VGND sky130_ef_sc_hd__decap_12
XFILLER_0_10_505 VPWR VGND VPWR VGND sky130_ef_sc_hd__decap_12
XFILLER_0_1_237 VGND VGND VPWR VPWR sky130_fd_sc_hd__decap_4
XFILLER_0_22_365 VGND VGND VPWR VPWR sky130_fd_sc_hd__decap_4
X_4190_ net5 _1059_ _1035_ _1065_ VGND VGND VPWR VPWR _0171_ sky130_fd_sc_hd__o211a_1
X_3210_ fifo3.mem\[15\]\[2\] _1838_ _1839_ VGND VGND VPWR VPWR _1840_ sky130_fd_sc_hd__o21ai_1
X_3141_ fifo3.mem\[4\]\[7\] _0842_ _1788_ VGND VGND VPWR VPWR _1797_ sky130_fd_sc_hd__a21bo_1
XFILLER_0_66_68 VGND VGND VPWR VPWR sky130_fd_sc_hd__decap_8
X_3072_ _0738_ _1754_ _1756_ _1757_ net103 VGND VGND VPWR VPWR _0460_ sky130_fd_sc_hd__a32o_1
XFILLER_0_77_505 VGND VGND VPWR VPWR sky130_fd_sc_hd__decap_6
XFILLER_0_77_516 VPWR VGND VPWR VGND sky130_ef_sc_hd__decap_12
X_3974_ _0917_ VGND VGND VPWR VPWR _0103_ sky130_fd_sc_hd__clkbuf_1
XFILLER_0_17_137 VPWR VGND VPWR VGND sky130_ef_sc_hd__decap_12
X_2925_ _1624_ _1626_ _1628_ VGND VGND VPWR VPWR _1629_ sky130_fd_sc_hd__o21ai_1
XFILLER_0_72_243 VGND VGND VPWR VPWR sky130_fd_sc_hd__decap_8
X_2856_ _0005_ VGND VGND VPWR VPWR _1562_ sky130_fd_sc_hd__clkbuf_4
XFILLER_0_31_82 VPWR VGND VPWR VGND sky130_ef_sc_hd__decap_12
Xhold211 fifo1.mem\[12\]\[7\] VGND VGND VPWR VPWR net259 sky130_fd_sc_hd__dlygate4sd3_1
XFILLER_0_79_3 VGND VGND VPWR VPWR sky130_fd_sc_hd__decap_8
Xhold200 fifo3.mem\[15\]\[5\] VGND VGND VPWR VPWR net248 sky130_fd_sc_hd__dlygate4sd3_1
X_2787_ fifo2.rd_pointer\[0\] _1504_ _1505_ VGND VGND VPWR VPWR _0427_ sky130_fd_sc_hd__a21oi_1
X_4526_ clknet_leaf_27_clock _0332_ VGND VGND VPWR VPWR fifo2.mem\[7\]\[0\] sky130_fd_sc_hd__dfxtp_1
Xhold233 fifo2.mem\[6\]\[0\] VGND VGND VPWR VPWR net281 sky130_fd_sc_hd__dlygate4sd3_1
Xhold244 fifo3.mem\[13\]\[3\] VGND VGND VPWR VPWR net292 sky130_fd_sc_hd__dlygate4sd3_1
Xhold222 fifo1.mem\[5\]\[5\] VGND VGND VPWR VPWR net270 sky130_fd_sc_hd__dlygate4sd3_1
X_4457_ clknet_leaf_17_clock _0263_ VGND VGND VPWR VPWR fifo1.count\[5\] sky130_fd_sc_hd__dfxtp_1
Xhold255 fifo1.mem\[9\]\[5\] VGND VGND VPWR VPWR net303 sky130_fd_sc_hd__dlygate4sd3_1
Xhold266 fifo1.mem\[4\]\[1\] VGND VGND VPWR VPWR net314 sky130_fd_sc_hd__dlygate4sd3_1
Xhold277 fifo2.mem\[9\]\[5\] VGND VGND VPWR VPWR net325 sky130_fd_sc_hd__dlygate4sd3_1
XFILLER_0_0_281 VPWR VGND VPWR VGND sky130_ef_sc_hd__decap_12
X_3408_ _1942_ fifo3.mem\[1\]\[8\] _2013_ VGND VGND VPWR VPWR _2014_ sky130_fd_sc_hd__o21ai_1
Xhold288 fifo2.mem\[15\]\[1\] VGND VGND VPWR VPWR net336 sky130_fd_sc_hd__dlygate4sd3_1
Xhold299 fifo2.mem\[6\]\[4\] VGND VGND VPWR VPWR net347 sky130_fd_sc_hd__dlygate4sd3_1
XTAP_560 VGND VPWR sky130_fd_sc_hd__tapvpwrvgnd_1
X_4388_ clknet_leaf_5_clock _0202_ VGND VGND VPWR VPWR fifo1.mem\[5\]\[8\] sky130_fd_sc_hd__dfxtp_1
Xclkbuf_3_7__f_clock clknet_0_clock VGND VGND VPWR VPWR clknet_3_7__leaf_clock sky130_fd_sc_hd__clkbuf_16
X_3339_ _1947_ _1953_ _0996_ _1964_ VGND VGND VPWR VPWR _0520_ sky130_fd_sc_hd__o211a_1
XTAP_571 VGND VPWR sky130_fd_sc_hd__tapvpwrvgnd_1
XTAP_582 VGND VPWR sky130_fd_sc_hd__tapvpwrvgnd_1
XTAP_593 VGND VPWR sky130_fd_sc_hd__tapvpwrvgnd_1
XFILLER_0_48_240 VGND VGND VPWR VPWR sky130_fd_sc_hd__decap_3
XFILLER_0_23_118 VGND VGND VPWR VPWR sky130_fd_sc_hd__decap_6
XFILLER_0_36_27 VGND VGND VPWR VPWR sky130_fd_sc_hd__fill_1
XFILLER_0_59_505 VGND VGND VPWR VPWR sky130_fd_sc_hd__decap_8
XFILLER_0_27_446 VGND VGND VPWR VPWR sky130_fd_sc_hd__fill_2
X_2710_ net210 _1478_ _1480_ _0938_ VGND VGND VPWR VPWR _0375_ sky130_fd_sc_hd__a22o_1
X_3690_ _0710_ _0711_ _0701_ VGND VGND VPWR VPWR _0025_ sky130_fd_sc_hd__a21oi_1
XFILLER_0_42_438 VGND VGND VPWR VPWR sky130_fd_sc_hd__decap_4
X_2641_ _0759_ _0981_ _1446_ _1453_ VGND VGND VPWR VPWR _0333_ sky130_fd_sc_hd__a31o_1
XFILLER_0_2_513 VPWR VGND VPWR VGND sky130_ef_sc_hd__decap_12
X_2572_ _0955_ VGND VGND VPWR VPWR _1431_ sky130_fd_sc_hd__clkbuf_4
Xclkbuf_leaf_31_clock clknet_3_7__leaf_clock VGND VGND VPWR VPWR clknet_leaf_31_clock
+ sky130_fd_sc_hd__clkbuf_16
XFILLER_0_22_184 VGND VGND VPWR VPWR sky130_fd_sc_hd__fill_1
X_4311_ clknet_leaf_23_clock _0125_ VGND VGND VPWR VPWR fifo2.mem\[1\]\[2\] sky130_fd_sc_hd__dfxtp_1
X_4242_ clknet_leaf_55_clock _0056_ VGND VGND VPWR VPWR fifo3.mem\[8\]\[3\] sky130_fd_sc_hd__dfxtp_1
X_4173_ _1054_ regis.internal_parity\[6\] _0874_ VGND VGND VPWR VPWR _1055_ sky130_fd_sc_hd__a21boi_1
Xclkbuf_leaf_46_clock clknet_3_5__leaf_clock VGND VGND VPWR VPWR clknet_leaf_46_clock
+ sky130_fd_sc_hd__clkbuf_16
X_3124_ _0939_ _1771_ _1787_ VGND VGND VPWR VPWR _0482_ sky130_fd_sc_hd__a21o_1
X_3055_ net308 _1749_ _1751_ _0927_ VGND VGND VPWR VPWR _0449_ sky130_fd_sc_hd__a22o_1
XFILLER_0_89_173 VGND VGND VPWR VPWR sky130_fd_sc_hd__fill_1
XFILLER_0_26_71 VGND VGND VPWR VPWR sky130_fd_sc_hd__fill_2
XFILLER_0_9_123 VGND VGND VPWR VPWR sky130_fd_sc_hd__fill_1
X_3957_ syn.count2\[5\] _0906_ VGND VGND VPWR VPWR _0909_ sky130_fd_sc_hd__or2_1
XFILLER_0_18_457 VGND VGND VPWR VPWR sky130_fd_sc_hd__decap_4
XFILLER_0_18_468 VGND VGND VPWR VPWR sky130_fd_sc_hd__decap_8
XFILLER_0_45_243 VGND VGND VPWR VPWR sky130_fd_sc_hd__fill_2
X_2908_ _1567_ fifo2.mem\[10\]\[3\] _1570_ VGND VGND VPWR VPWR _1613_ sky130_fd_sc_hd__o21a_1
X_3888_ _0855_ _0856_ net331 _0857_ _0862_ VGND VGND VPWR VPWR _0072_ sky130_fd_sc_hd__a32o_1
X_2839_ fifo2.mem\[0\]\[8\] fifo2.mem\[1\]\[8\] fifo2.mem\[2\]\[8\] fifo2.mem\[3\]\[8\]
+ _1539_ _1540_ VGND VGND VPWR VPWR _1545_ sky130_fd_sc_hd__mux4_1
XFILLER_0_33_449 VGND VGND VPWR VPWR sky130_fd_sc_hd__fill_1
XFILLER_0_60_235 VGND VGND VPWR VPWR sky130_fd_sc_hd__decap_8
XFILLER_0_13_151 VGND VGND VPWR VPWR sky130_fd_sc_hd__decap_4
X_4509_ clknet_leaf_40_clock _0315_ VGND VGND VPWR VPWR fifo2.mem\[9\]\[1\] sky130_fd_sc_hd__dfxtp_1
XTAP_390 VGND VPWR sky130_fd_sc_hd__tapvpwrvgnd_1
XFILLER_0_68_302 VGND VGND VPWR VPWR sky130_fd_sc_hd__decap_6
XPHY_30 VGND VGND VPWR VPWR sky130_fd_sc_hd__decap_3
XPHY_41 VGND VGND VPWR VPWR sky130_fd_sc_hd__decap_3
XPHY_52 VGND VGND VPWR VPWR sky130_fd_sc_hd__decap_3
XPHY_63 VGND VGND VPWR VPWR sky130_fd_sc_hd__decap_3
XPHY_74 VGND VGND VPWR VPWR sky130_fd_sc_hd__decap_3
XFILLER_0_83_349 VPWR VGND VPWR VGND sky130_ef_sc_hd__decap_12
XPHY_85 VGND VGND VPWR VPWR sky130_fd_sc_hd__decap_3
XPHY_96 VGND VGND VPWR VPWR sky130_fd_sc_hd__decap_3
XFILLER_0_51_213 VGND VGND VPWR VPWR sky130_fd_sc_hd__fill_2
XFILLER_0_91_393 VPWR VGND VPWR VGND sky130_ef_sc_hd__decap_12
XFILLER_0_17_490 VPWR VGND VPWR VGND sky130_ef_sc_hd__decap_12
XFILLER_0_36_298 VGND VGND VPWR VPWR sky130_fd_sc_hd__decap_8
XFILLER_0_32_493 VPWR VGND VPWR VGND sky130_ef_sc_hd__decap_12
XFILLER_0_63_36 VGND VGND VPWR VPWR sky130_fd_sc_hd__decap_4
XFILLER_0_86_110 VGND VGND VPWR VPWR sky130_fd_sc_hd__fill_1
XFILLER_0_59_368 VGND VGND VPWR VPWR sky130_fd_sc_hd__fill_1
X_3811_ _0804_ VGND VGND VPWR VPWR _0805_ sky130_fd_sc_hd__clkbuf_4
XFILLER_0_6_115 VGND VGND VPWR VPWR sky130_fd_sc_hd__fill_1
X_4791_ clknet_leaf_48_clock _0597_ VGND VGND VPWR VPWR fifo3.mem\[13\]\[1\] sky130_fd_sc_hd__dfxtp_1
X_3742_ _0748_ _0750_ _0751_ _0753_ VGND VGND VPWR VPWR _0754_ sky130_fd_sc_hd__and4b_1
X_3673_ syn.count0\[1\] syn.count0\[5\] syn.count0\[4\] syn.count0\[0\] VGND VGND
+ VPWR VPWR _0699_ sky130_fd_sc_hd__and4bb_1
XFILLER_0_42_224 VGND VGND VPWR VPWR sky130_fd_sc_hd__decap_4
XFILLER_0_70_533 VGND VGND VPWR VPWR sky130_fd_sc_hd__decap_8
XFILLER_0_30_419 VGND VGND VPWR VPWR sky130_fd_sc_hd__fill_1
X_2624_ net227 _1437_ _1442_ _1444_ _0734_ VGND VGND VPWR VPWR _0325_ sky130_fd_sc_hd__a32o_1
XFILLER_0_88_77 VGND VGND VPWR VPWR sky130_fd_sc_hd__decap_6
XFILLER_0_2_365 VPWR VGND VPWR VGND sky130_ef_sc_hd__decap_12
X_2555_ _0797_ _1416_ _0830_ _1423_ VGND VGND VPWR VPWR _0277_ sky130_fd_sc_hd__a31o_1
X_2486_ _1359_ _1365_ _1368_ VGND VGND VPWR VPWR _1369_ sky130_fd_sc_hd__a21oi_1
X_4225_ clknet_leaf_11_clock _0039_ VGND VGND VPWR VPWR fifo1.mem\[0\]\[4\] sky130_fd_sc_hd__dfxtp_1
X_4156_ regis.internal_parity\[0\] _1041_ _1043_ VGND VGND VPWR VPWR _0159_ sky130_fd_sc_hd__o21a_1
X_3107_ _0926_ _1771_ _1777_ VGND VGND VPWR VPWR _0475_ sky130_fd_sc_hd__a21o_1
X_4087_ _0659_ _0986_ _0989_ _0991_ VGND VGND VPWR VPWR _0992_ sky130_fd_sc_hd__o211ai_1
X_3038_ fifo2.count\[5\] fifo2.count\[4\] fifo2.count\[3\] _1620_ VGND VGND VPWR VPWR
+ _1739_ sky130_fd_sc_hd__or4_1
XFILLER_0_77_198 VGND VGND VPWR VPWR sky130_fd_sc_hd__fill_1
XFILLER_0_65_327 VGND VGND VPWR VPWR sky130_fd_sc_hd__decap_8
XFILLER_0_61_500 VGND VGND VPWR VPWR sky130_fd_sc_hd__decap_4
XFILLER_0_83_113 VGND VGND VPWR VPWR sky130_fd_sc_hd__decap_3
XFILLER_0_71_308 VGND VGND VPWR VPWR sky130_fd_sc_hd__fill_2
XFILLER_0_24_224 VGND VGND VPWR VPWR sky130_fd_sc_hd__fill_2
XFILLER_0_64_382 VGND VGND VPWR VPWR sky130_fd_sc_hd__fill_1
XFILLER_0_12_408 VPWR VGND VPWR VGND sky130_ef_sc_hd__decap_12
X_2340_ _1199_ _1202_ _1227_ VGND VGND VPWR VPWR _1228_ sky130_fd_sc_hd__o21ai_1
X_2271_ _1162_ _0983_ VGND VGND VPWR VPWR _1163_ sky130_fd_sc_hd__nand2_1
X_4010_ _0942_ VGND VGND VPWR VPWR _0943_ sky130_fd_sc_hd__clkbuf_4
XFILLER_0_59_110 VGND VGND VPWR VPWR sky130_fd_sc_hd__fill_2
XFILLER_0_87_485 VPWR VGND VPWR VGND sky130_ef_sc_hd__decap_12
XFILLER_0_59_176 VGND VGND VPWR VPWR sky130_fd_sc_hd__fill_2
XFILLER_0_7_446 VGND VGND VPWR VPWR sky130_fd_sc_hd__fill_2
X_4774_ clknet_leaf_57_clock _0580_ VGND VGND VPWR VPWR fifo3.mem\[11\]\[2\] sky130_fd_sc_hd__dfxtp_1
XFILLER_0_43_533 VGND VGND VPWR VPWR sky130_fd_sc_hd__decap_8
X_3725_ _0723_ VGND VGND VPWR VPWR _0741_ sky130_fd_sc_hd__clkbuf_4
X_3656_ fsm1.present_state\[4\] _0654_ VGND VGND VPWR VPWR _0688_ sky130_fd_sc_hd__nand2_1
XFILLER_0_30_205 VPWR VGND VPWR VGND sky130_ef_sc_hd__decap_12
XFILLER_0_30_227 VGND VGND VPWR VPWR sky130_fd_sc_hd__decap_8
X_2607_ _1438_ _0859_ fifo1.temp _0860_ VGND VGND VPWR VPWR _1440_ sky130_fd_sc_hd__and4b_1
X_3587_ fifo2.rd_pointer\[0\] fifo2.wr_pointer\[0\] VGND VGND VPWR VPWR _0625_ sky130_fd_sc_hd__xnor2_4
X_2538_ _1415_ VGND VGND VPWR VPWR _0268_ sky130_fd_sc_hd__clkbuf_1
X_4208_ clknet_leaf_25_clock _0022_ VGND VGND VPWR VPWR syn.count0\[2\] sky130_fd_sc_hd__dfxtp_1
X_2469_ _1208_ _1213_ VGND VGND VPWR VPWR _1352_ sky130_fd_sc_hd__nand2_1
X_4139_ _1026_ _0680_ _0656_ regis.header_byte\[3\] VGND VGND VPWR VPWR _1033_ sky130_fd_sc_hd__a31o_1
XFILLER_0_65_146 VGND VGND VPWR VPWR sky130_fd_sc_hd__fill_2
XFILLER_0_80_105 VGND VGND VPWR VPWR sky130_fd_sc_hd__decap_8
XFILLER_0_80_138 VGND VGND VPWR VPWR sky130_fd_sc_hd__fill_2
XFILLER_0_34_533 VGND VGND VPWR VPWR sky130_fd_sc_hd__decap_8
XFILLER_0_44_27 VGND VGND VPWR VPWR sky130_fd_sc_hd__fill_1
XFILLER_0_69_430 VPWR VGND VPWR VGND sky130_ef_sc_hd__decap_12
XFILLER_0_56_135 VGND VGND VPWR VPWR sky130_fd_sc_hd__decap_4
XFILLER_0_60_15 VGND VGND VPWR VPWR sky130_fd_sc_hd__fill_2
XFILLER_0_84_477 VPWR VGND VPWR VGND sky130_ef_sc_hd__decap_12
XFILLER_0_37_393 VGND VGND VPWR VPWR sky130_fd_sc_hd__decap_6
XFILLER_0_8_27 VGND VGND VPWR VPWR sky130_fd_sc_hd__fill_1
X_3510_ _1760_ _1779_ _1781_ fifo3.mem\[10\]\[1\] _1783_ VGND VGND VPWR VPWR _2086_
+ sky130_fd_sc_hd__o311a_1
XFILLER_0_12_205 VGND VGND VPWR VPWR sky130_fd_sc_hd__fill_1
X_4490_ clknet_leaf_38_clock _0296_ VGND VGND VPWR VPWR fifo2.mem\[12\]\[0\] sky130_fd_sc_hd__dfxtp_1
XFILLER_0_40_525 VGND VGND VPWR VPWR sky130_fd_sc_hd__decap_6
XFILLER_0_69_57 VGND VGND VPWR VPWR sky130_fd_sc_hd__decap_3
X_3441_ _1919_ _1922_ _1827_ VGND VGND VPWR VPWR _2044_ sky130_fd_sc_hd__o21ai_1
XFILLER_0_69_68 VGND VGND VPWR VPWR sky130_fd_sc_hd__decap_3
XTAP_901 VGND VPWR sky130_fd_sc_hd__tapvpwrvgnd_1
X_3372_ _1987_ VGND VGND VPWR VPWR _0530_ sky130_fd_sc_hd__clkbuf_1
XTAP_934 VGND VPWR sky130_fd_sc_hd__tapvpwrvgnd_1
XTAP_923 VGND VPWR sky130_fd_sc_hd__tapvpwrvgnd_1
XTAP_912 VGND VPWR sky130_fd_sc_hd__tapvpwrvgnd_1
X_2323_ _1188_ fifo1.mem\[2\]\[2\] _1177_ VGND VGND VPWR VPWR _1211_ sky130_fd_sc_hd__o21a_1
XTAP_978 VGND VPWR sky130_fd_sc_hd__tapvpwrvgnd_1
XTAP_967 VGND VPWR sky130_fd_sc_hd__tapvpwrvgnd_1
XTAP_956 VGND VPWR sky130_fd_sc_hd__tapvpwrvgnd_1
XTAP_945 VGND VPWR sky130_fd_sc_hd__tapvpwrvgnd_1
XTAP_989 VGND VPWR sky130_fd_sc_hd__tapvpwrvgnd_1
X_2254_ _0749_ _1143_ _0613_ VGND VGND VPWR VPWR _1149_ sky130_fd_sc_hd__a21bo_1
XFILLER_0_79_205 VGND VGND VPWR VPWR sky130_fd_sc_hd__fill_2
X_2185_ _1110_ _1117_ _1118_ net178 VGND VGND VPWR VPWR _0212_ sky130_fd_sc_hd__a22o_1
XFILLER_0_47_113 VGND VGND VPWR VPWR sky130_fd_sc_hd__fill_1
XFILLER_0_87_293 VGND VGND VPWR VPWR sky130_fd_sc_hd__decap_3
XFILLER_0_16_533 VGND VGND VPWR VPWR sky130_fd_sc_hd__decap_8
XFILLER_0_7_254 VGND VGND VPWR VPWR sky130_fd_sc_hd__decap_3
XFILLER_0_28_371 VGND VGND VPWR VPWR sky130_fd_sc_hd__fill_2
X_4757_ clknet_leaf_33_clock _0563_ VGND VGND VPWR VPWR fifo2.mem\[11\]\[3\] sky130_fd_sc_hd__dfxtp_1
X_4688_ clknet_leaf_32_clock _0494_ VGND VGND VPWR VPWR _0006_ sky130_fd_sc_hd__dfxtp_2
X_3708_ _0719_ VGND VGND VPWR VPWR _0729_ sky130_fd_sc_hd__clkbuf_4
X_3639_ fsm1.detect_add VGND VGND VPWR VPWR _0674_ sky130_fd_sc_hd__inv_2
XFILLER_0_66_477 VGND VGND VPWR VPWR sky130_fd_sc_hd__decap_4
XFILLER_0_19_393 VGND VGND VPWR VPWR sky130_fd_sc_hd__decap_3
XFILLER_0_30_29 VPWR VGND VPWR VGND sky130_ef_sc_hd__decap_12
XFILLER_0_34_396 VGND VGND VPWR VPWR sky130_fd_sc_hd__fill_1
XFILLER_0_39_27 VPWR VGND VPWR VGND sky130_ef_sc_hd__decap_12
XTAP_208 VGND VPWR sky130_fd_sc_hd__tapvpwrvgnd_1
XTAP_219 VGND VPWR sky130_fd_sc_hd__tapvpwrvgnd_1
Xhold4 fifo3.mem\[3\]\[2\] VGND VGND VPWR VPWR net52 sky130_fd_sc_hd__dlygate4sd3_1
XFILLER_0_55_15 VGND VGND VPWR VPWR sky130_fd_sc_hd__decap_4
X_3990_ _0927_ _0924_ _0929_ VGND VGND VPWR VPWR _0107_ sky130_fd_sc_hd__a21o_1
XFILLER_0_29_113 VGND VGND VPWR VPWR sky130_fd_sc_hd__decap_6
XFILLER_0_29_135 VGND VGND VPWR VPWR sky130_fd_sc_hd__decap_6
X_2941_ _1582_ fifo2.mem\[1\]\[4\] _1644_ VGND VGND VPWR VPWR _1645_ sky130_fd_sc_hd__o21ai_1
XFILLER_0_84_296 VGND VGND VPWR VPWR sky130_fd_sc_hd__fill_2
XFILLER_0_72_447 VPWR VGND VPWR VGND sky130_ef_sc_hd__decap_12
XFILLER_0_44_127 VPWR VGND VPWR VGND sky130_ef_sc_hd__decap_12
X_2872_ _1556_ fifo2.mem\[14\]\[2\] _1558_ VGND VGND VPWR VPWR _1578_ sky130_fd_sc_hd__o21a_1
X_4611_ clknet_leaf_6_clock _0417_ VGND VGND VPWR VPWR fifo1.mem\[4\]\[4\] sky130_fd_sc_hd__dfxtp_1
XFILLER_0_4_213 VGND VGND VPWR VPWR sky130_fd_sc_hd__fill_2
X_4542_ clknet_leaf_16_clock _0348_ VGND VGND VPWR VPWR fifo1.mem\[12\]\[7\] sky130_fd_sc_hd__dfxtp_1
XFILLER_0_4_235 VGND VGND VPWR VPWR sky130_fd_sc_hd__fill_1
X_4473_ clknet_leaf_38_clock _0279_ VGND VGND VPWR VPWR fifo2.mem\[14\]\[1\] sky130_fd_sc_hd__dfxtp_1
XFILLER_0_40_333 VGND VGND VPWR VPWR sky130_fd_sc_hd__decap_3
XFILLER_0_40_344 VGND VGND VPWR VPWR sky130_fd_sc_hd__decap_4
XFILLER_0_52_193 VGND VGND VPWR VPWR sky130_fd_sc_hd__decap_3
X_3424_ _1891_ _1878_ VGND VGND VPWR VPWR _2029_ sky130_fd_sc_hd__nand2_1
X_3355_ _0831_ _0784_ _1978_ VGND VGND VPWR VPWR _0522_ sky130_fd_sc_hd__o21a_1
XTAP_720 VGND VPWR sky130_fd_sc_hd__tapvpwrvgnd_1
XTAP_731 VGND VPWR sky130_fd_sc_hd__tapvpwrvgnd_1
XTAP_742 VGND VPWR sky130_fd_sc_hd__tapvpwrvgnd_1
X_2306_ _1180_ _1181_ _1186_ _1191_ _1193_ VGND VGND VPWR VPWR _1194_ sky130_fd_sc_hd__a32oi_2
X_3286_ _1911_ _1913_ _1811_ VGND VGND VPWR VPWR _1914_ sky130_fd_sc_hd__a21o_1
XTAP_753 VGND VPWR sky130_fd_sc_hd__tapvpwrvgnd_1
XTAP_764 VGND VPWR sky130_fd_sc_hd__tapvpwrvgnd_1
XTAP_775 VGND VPWR sky130_fd_sc_hd__tapvpwrvgnd_1
XTAP_786 VGND VPWR sky130_fd_sc_hd__tapvpwrvgnd_1
X_2237_ _0750_ _1143_ _1102_ VGND VGND VPWR VPWR _1144_ sky130_fd_sc_hd__a21oi_4
XTAP_797 VGND VPWR sky130_fd_sc_hd__tapvpwrvgnd_1
X_2168_ _0610_ _0616_ _0605_ _0752_ VGND VGND VPWR VPWR _1111_ sky130_fd_sc_hd__a31oi_4
XFILLER_0_90_233 VPWR VGND VPWR VGND sky130_ef_sc_hd__decap_12
XFILLER_0_90_277 VPWR VGND VPWR VGND sky130_ef_sc_hd__decap_12
XFILLER_0_71_480 VPWR VGND VPWR VGND sky130_ef_sc_hd__decap_12
XFILLER_0_58_208 VGND VGND VPWR VPWR sky130_fd_sc_hd__decap_4
XFILLER_0_41_39 VPWR VGND VPWR VGND sky130_ef_sc_hd__decap_12
XFILLER_0_66_241 VGND VGND VPWR VPWR sky130_fd_sc_hd__decap_4
XFILLER_0_54_458 VGND VGND VPWR VPWR sky130_fd_sc_hd__decap_3
XFILLER_0_1_205 VGND VGND VPWR VPWR sky130_fd_sc_hd__decap_3
XFILLER_0_62_480 VPWR VGND VPWR VGND sky130_ef_sc_hd__decap_12
XFILLER_0_10_517 VPWR VGND VPWR VGND sky130_ef_sc_hd__decap_12
X_3140_ _0936_ _1789_ _1796_ VGND VGND VPWR VPWR _0489_ sky130_fd_sc_hd__o21a_1
X_3071_ _0736_ _1754_ _1756_ _1757_ net203 VGND VGND VPWR VPWR _0459_ sky130_fd_sc_hd__a32o_1
XFILLER_0_77_528 VPWR VGND VPWR VGND sky130_ef_sc_hd__decap_12
XFILLER_0_15_73 VPWR VGND VPWR VGND sky130_ef_sc_hd__decap_12
X_3973_ net7 regis.fifo_full_state\[6\] _0910_ VGND VGND VPWR VPWR _0917_ sky130_fd_sc_hd__mux2_1
X_2924_ _1623_ _1627_ _1565_ _1538_ VGND VGND VPWR VPWR _1628_ sky130_fd_sc_hd__o211ai_1
X_2855_ fifo2.mem\[7\]\[2\] VGND VGND VPWR VPWR _1561_ sky130_fd_sc_hd__inv_2
XFILLER_0_17_149 VPWR VGND VPWR VGND sky130_ef_sc_hd__decap_12
XFILLER_0_45_447 VGND VGND VPWR VPWR sky130_fd_sc_hd__fill_1
XFILLER_0_31_94 VGND VGND VPWR VPWR sky130_fd_sc_hd__decap_8
Xhold201 fifo2.mem\[6\]\[7\] VGND VGND VPWR VPWR net249 sky130_fd_sc_hd__dlygate4sd3_1
X_2786_ fifo2.rd_pointer\[0\] _1504_ _0983_ VGND VGND VPWR VPWR _1505_ sky130_fd_sc_hd__o21ai_1
X_4525_ clknet_leaf_24_clock _0331_ VGND VGND VPWR VPWR fifo2.mem\[4\]\[8\] sky130_fd_sc_hd__dfxtp_1
Xhold234 fifo1.mem\[15\]\[0\] VGND VGND VPWR VPWR net282 sky130_fd_sc_hd__dlygate4sd3_1
Xhold212 fifo1.mem\[1\]\[6\] VGND VGND VPWR VPWR net260 sky130_fd_sc_hd__dlygate4sd3_1
Xhold223 fifo1.mem\[10\]\[8\] VGND VGND VPWR VPWR net271 sky130_fd_sc_hd__dlygate4sd3_1
Xhold267 fifo1.mem\[13\]\[5\] VGND VGND VPWR VPWR net315 sky130_fd_sc_hd__dlygate4sd3_1
Xhold256 fifo1.mem\[14\]\[8\] VGND VGND VPWR VPWR net304 sky130_fd_sc_hd__dlygate4sd3_1
X_4456_ clknet_leaf_17_clock _0262_ VGND VGND VPWR VPWR fifo1.count\[4\] sky130_fd_sc_hd__dfxtp_1
Xhold245 fifo3.mem\[15\]\[4\] VGND VGND VPWR VPWR net293 sky130_fd_sc_hd__dlygate4sd3_1
Xhold278 fifo3.mem\[12\]\[2\] VGND VGND VPWR VPWR net326 sky130_fd_sc_hd__dlygate4sd3_1
XFILLER_0_0_260 VGND VGND VPWR VPWR sky130_fd_sc_hd__decap_4
X_3407_ _1828_ fifo3.mem\[0\]\[8\] _1857_ VGND VGND VPWR VPWR _2013_ sky130_fd_sc_hd__o21ba_1
Xhold289 fifo1.mem\[6\]\[4\] VGND VGND VPWR VPWR net337 sky130_fd_sc_hd__dlygate4sd3_1
X_4387_ clknet_leaf_5_clock _0201_ VGND VGND VPWR VPWR fifo1.mem\[5\]\[7\] sky130_fd_sc_hd__dfxtp_1
XFILLER_0_0_293 VGND VGND VPWR VPWR sky130_fd_sc_hd__decap_8
X_3338_ _1816_ _1958_ _1963_ VGND VGND VPWR VPWR _1964_ sky130_fd_sc_hd__nand3_1
XTAP_550 VGND VPWR sky130_fd_sc_hd__tapvpwrvgnd_1
XTAP_561 VGND VPWR sky130_fd_sc_hd__tapvpwrvgnd_1
XTAP_572 VGND VPWR sky130_fd_sc_hd__tapvpwrvgnd_1
XTAP_583 VGND VPWR sky130_fd_sc_hd__tapvpwrvgnd_1
XTAP_594 VGND VPWR sky130_fd_sc_hd__tapvpwrvgnd_1
X_3269_ fifo3.mem\[15\]\[4\] _1838_ _1896_ VGND VGND VPWR VPWR _1897_ sky130_fd_sc_hd__o21ai_1
XFILLER_0_68_506 VGND VGND VPWR VPWR sky130_fd_sc_hd__decap_6
XFILLER_0_39_241 VGND VGND VPWR VPWR sky130_fd_sc_hd__fill_1
XFILLER_0_82_531 VGND VGND VPWR VPWR sky130_fd_sc_hd__fill_1
X_2640_ _1447_ _1448_ _1450_ _1451_ fifo2.mem\[7\]\[1\] VGND VGND VPWR VPWR _1453_
+ sky130_fd_sc_hd__o311a_1
XFILLER_0_2_525 VGND VGND VPWR VPWR sky130_fd_sc_hd__decap_6
XFILLER_0_22_141 VGND VGND VPWR VPWR sky130_fd_sc_hd__decap_4
X_2571_ _0745_ _1425_ _1429_ _1430_ net88 VGND VGND VPWR VPWR _0286_ sky130_fd_sc_hd__a32o_1
X_4310_ clknet_leaf_28_clock _0124_ VGND VGND VPWR VPWR fifo2.mem\[1\]\[1\] sky130_fd_sc_hd__dfxtp_1
XFILLER_0_50_483 VGND VGND VPWR VPWR sky130_fd_sc_hd__decap_6
X_4241_ clknet_leaf_56_clock _0055_ VGND VGND VPWR VPWR fifo3.mem\[8\]\[2\] sky130_fd_sc_hd__dfxtp_1
XFILLER_0_58_9 VGND VGND VPWR VPWR sky130_fd_sc_hd__fill_1
X_4172_ regis.header_byte\[6\] _0993_ _1040_ net7 VGND VGND VPWR VPWR _1054_ sky130_fd_sc_hd__a22o_1
X_3123_ _0839_ _1779_ _1781_ fifo3.mem\[9\]\[8\] _1783_ VGND VGND VPWR VPWR _1787_
+ sky130_fd_sc_hd__o311a_1
X_3054_ net276 _1749_ _1751_ _0759_ VGND VGND VPWR VPWR _0448_ sky130_fd_sc_hd__a22o_1
XFILLER_0_26_83 VGND VGND VPWR VPWR sky130_fd_sc_hd__fill_1
XFILLER_0_77_369 VGND VGND VPWR VPWR sky130_fd_sc_hd__fill_1
X_3956_ _0906_ syn.count2\[5\] VGND VGND VPWR VPWR _0908_ sky130_fd_sc_hd__nand2_1
X_2907_ _1582_ fifo2.mem\[9\]\[3\] _1611_ VGND VGND VPWR VPWR _1612_ sky130_fd_sc_hd__o21ai_1
XFILLER_0_91_3 VPWR VGND VPWR VGND sky130_ef_sc_hd__decap_12
X_3887_ _0725_ _0858_ _0731_ _0860_ VGND VGND VPWR VPWR _0862_ sky130_fd_sc_hd__and4b_1
XFILLER_0_45_266 VGND VGND VPWR VPWR sky130_fd_sc_hd__decap_6
XFILLER_0_33_439 VGND VGND VPWR VPWR sky130_fd_sc_hd__fill_1
X_2838_ _0006_ VGND VGND VPWR VPWR _1544_ sky130_fd_sc_hd__inv_2
X_2769_ _1108_ _1494_ _1495_ net145 VGND VGND VPWR VPWR _0419_ sky130_fd_sc_hd__a22o_1
X_4508_ clknet_leaf_40_clock _0314_ VGND VGND VPWR VPWR fifo2.mem\[9\]\[0\] sky130_fd_sc_hd__dfxtp_1
X_4439_ clknet_leaf_13_clock _0245_ VGND VGND VPWR VPWR fifo1.mem\[3\]\[6\] sky130_fd_sc_hd__dfxtp_1
XTAP_380 VGND VPWR sky130_fd_sc_hd__tapvpwrvgnd_1
XTAP_391 VGND VPWR sky130_fd_sc_hd__tapvpwrvgnd_1
XPHY_31 VGND VGND VPWR VPWR sky130_fd_sc_hd__decap_3
XPHY_20 VGND VGND VPWR VPWR sky130_fd_sc_hd__decap_3
XPHY_42 VGND VGND VPWR VPWR sky130_fd_sc_hd__decap_3
XPHY_53 VGND VGND VPWR VPWR sky130_fd_sc_hd__decap_3
XPHY_64 VGND VGND VPWR VPWR sky130_fd_sc_hd__decap_3
XPHY_75 VGND VGND VPWR VPWR sky130_fd_sc_hd__decap_3
XPHY_86 VGND VGND VPWR VPWR sky130_fd_sc_hd__decap_3
XPHY_97 VGND VGND VPWR VPWR sky130_fd_sc_hd__decap_3
XFILLER_0_91_361 VGND VGND VPWR VPWR sky130_fd_sc_hd__decap_3
XFILLER_0_51_225 VGND VGND VPWR VPWR sky130_fd_sc_hd__decap_3
XFILLER_0_51_269 VGND VGND VPWR VPWR sky130_fd_sc_hd__fill_1
XFILLER_0_47_27 VPWR VGND VPWR VGND sky130_ef_sc_hd__decap_12
XFILLER_0_2_29 VGND VGND VPWR VPWR sky130_fd_sc_hd__fill_1
XFILLER_0_74_306 VGND VGND VPWR VPWR sky130_fd_sc_hd__fill_2
X_4790_ clknet_leaf_48_clock _0596_ VGND VGND VPWR VPWR fifo3.mem\[13\]\[0\] sky130_fd_sc_hd__dfxtp_1
X_3810_ _0769_ _0780_ _0802_ _0803_ VGND VGND VPWR VPWR _0804_ sky130_fd_sc_hd__and4b_1
X_3741_ _0610_ _0616_ _0605_ _0752_ fifo1.wr_pointer\[1\] VGND VGND VPWR VPWR _0753_
+ sky130_fd_sc_hd__a311oi_4
XFILLER_0_67_391 VGND VGND VPWR VPWR sky130_fd_sc_hd__fill_1
XFILLER_0_42_203 VGND VGND VPWR VPWR sky130_fd_sc_hd__fill_1
X_3672_ syn.count0\[0\] syn.count0\[1\] VGND VGND VPWR VPWR _0698_ sky130_fd_sc_hd__xnor2_1
XFILLER_0_12_85 VGND VGND VPWR VPWR sky130_fd_sc_hd__decap_8
X_2623_ net244 _1437_ _1442_ _1444_ _0732_ VGND VGND VPWR VPWR _0324_ sky130_fd_sc_hd__a32o_1
XFILLER_0_23_461 VGND VGND VPWR VPWR sky130_fd_sc_hd__decap_8
X_2554_ _0833_ _1420_ _0841_ _0844_ fifo3.mem\[3\]\[8\] VGND VGND VPWR VPWR _1423_
+ sky130_fd_sc_hd__o311a_1
XFILLER_0_2_377 VPWR VGND VPWR VGND sky130_ef_sc_hd__decap_12
X_2485_ _1265_ _1270_ _1366_ _1367_ VGND VGND VPWR VPWR _1368_ sky130_fd_sc_hd__o2bb2ai_1
X_4224_ clknet_leaf_11_clock _0038_ VGND VGND VPWR VPWR fifo1.mem\[0\]\[3\] sky130_fd_sc_hd__dfxtp_1
X_4155_ _1041_ regis.internal_parity\[0\] _1042_ VGND VGND VPWR VPWR _1043_ sky130_fd_sc_hd__a21boi_1
X_3106_ _0839_ _1772_ _1774_ fifo3.mem\[9\]\[1\] _1775_ VGND VGND VPWR VPWR _1777_
+ sky130_fd_sc_hd__o311a_1
X_4086_ regis.fifo_full_state\[0\] _0990_ _0690_ VGND VGND VPWR VPWR _0991_ sky130_fd_sc_hd__o21ba_1
X_3037_ _1722_ _1723_ _1734_ _1737_ VGND VGND VPWR VPWR _1738_ sky130_fd_sc_hd__o211ai_1
XFILLER_0_53_92 VGND VGND VPWR VPWR sky130_fd_sc_hd__decap_4
XFILLER_0_46_531 VGND VGND VPWR VPWR sky130_fd_sc_hd__fill_1
X_3939_ syn.count2\[1\] syn.count2\[0\] VGND VGND VPWR VPWR _0895_ sky130_fd_sc_hd__and2b_1
XFILLER_0_61_534 VGND VGND VPWR VPWR sky130_fd_sc_hd__decap_6
Xclkbuf_leaf_30_clock clknet_3_7__leaf_clock VGND VGND VPWR VPWR clknet_leaf_30_clock
+ sky130_fd_sc_hd__clkbuf_16
XFILLER_0_56_306 VGND VGND VPWR VPWR sky130_fd_sc_hd__fill_2
XFILLER_0_56_317 VGND VGND VPWR VPWR sky130_fd_sc_hd__fill_2
XFILLER_0_83_169 VGND VGND VPWR VPWR sky130_fd_sc_hd__decap_6
XFILLER_0_24_203 VPWR VGND VPWR VGND sky130_ef_sc_hd__decap_12
XFILLER_0_64_361 VGND VGND VPWR VPWR sky130_fd_sc_hd__decap_3
Xclkbuf_leaf_45_clock clknet_3_5__leaf_clock VGND VGND VPWR VPWR clknet_leaf_45_clock
+ sky130_fd_sc_hd__clkbuf_16
XFILLER_0_3_108 VGND VGND VPWR VPWR sky130_fd_sc_hd__decap_4
XFILLER_0_64_372 VGND VGND VPWR VPWR sky130_fd_sc_hd__decap_3
XFILLER_0_3_119 VGND VGND VPWR VPWR sky130_fd_sc_hd__fill_1
XFILLER_0_24_247 VGND VGND VPWR VPWR sky130_fd_sc_hd__decap_4
X_2270_ _1155_ _1160_ fifo1.rd_pointer\[1\] VGND VGND VPWR VPWR _1162_ sky130_fd_sc_hd__a21o_1
XFILLER_0_74_25 VGND VGND VPWR VPWR sky130_fd_sc_hd__decap_3
XFILLER_0_87_497 VGND VGND VPWR VPWR sky130_fd_sc_hd__decap_6
XFILLER_0_28_531 VGND VGND VPWR VPWR sky130_fd_sc_hd__fill_1
X_4773_ clknet_leaf_58_clock _0579_ VGND VGND VPWR VPWR fifo3.mem\[11\]\[1\] sky130_fd_sc_hd__dfxtp_1
XFILLER_0_23_84 VPWR VGND VPWR VGND sky130_ef_sc_hd__decap_12
XFILLER_0_62_309 VGND VGND VPWR VPWR sky130_fd_sc_hd__fill_2
XFILLER_0_15_225 VGND VGND VPWR VPWR sky130_fd_sc_hd__decap_8
X_3724_ _0739_ VGND VGND VPWR VPWR _0740_ sky130_fd_sc_hd__clkbuf_8
XFILLER_0_7_469 VGND VGND VPWR VPWR sky130_fd_sc_hd__decap_8
XFILLER_0_55_383 VGND VGND VPWR VPWR sky130_fd_sc_hd__fill_1
X_3655_ _0656_ _0669_ _0654_ VGND VGND VPWR VPWR _0687_ sky130_fd_sc_hd__nand3_1
XFILLER_0_70_353 VGND VGND VPWR VPWR sky130_fd_sc_hd__decap_4
XFILLER_0_30_217 VGND VGND VPWR VPWR sky130_fd_sc_hd__decap_6
X_2606_ _1435_ _1437_ net348 _1439_ _1426_ VGND VGND VPWR VPWR _0312_ sky130_fd_sc_hd__a32o_1
XFILLER_0_2_141 VGND VGND VPWR VPWR sky130_fd_sc_hd__decap_6
X_3586_ _0620_ _0621_ _0622_ _0623_ VGND VGND VPWR VPWR _0624_ sky130_fd_sc_hd__o22a_2
X_2537_ _1413_ _1169_ _1414_ VGND VGND VPWR VPWR _1415_ sky130_fd_sc_hd__and3b_1
X_2468_ _1330_ _1351_ _0757_ VGND VGND VPWR VPWR _0262_ sky130_fd_sc_hd__a21oi_1
XFILLER_0_54_3 VGND VGND VPWR VPWR sky130_fd_sc_hd__decap_6
X_4207_ clknet_leaf_25_clock _0021_ VGND VGND VPWR VPWR syn.count0\[1\] sky130_fd_sc_hd__dfxtp_1
X_2399_ _1199_ _1202_ _1284_ VGND VGND VPWR VPWR _1285_ sky130_fd_sc_hd__o21ai_1
X_4138_ net3 _1027_ _0875_ _1032_ VGND VGND VPWR VPWR _0152_ sky130_fd_sc_hd__o211a_1
X_4069_ _0976_ _0867_ net342 _0971_ _0979_ VGND VGND VPWR VPWR _0136_ sky130_fd_sc_hd__a32o_1
XFILLER_0_6_491 VPWR VGND VPWR VGND sky130_ef_sc_hd__decap_12
XFILLER_0_21_217 VGND VGND VPWR VPWR sky130_fd_sc_hd__decap_6
XFILLER_0_14_291 VGND VGND VPWR VPWR sky130_fd_sc_hd__fill_1
XFILLER_0_28_29 VPWR VGND VPWR VGND sky130_ef_sc_hd__decap_12
XFILLER_0_69_442 VGND VGND VPWR VPWR sky130_fd_sc_hd__decap_6
XFILLER_0_69_453 VGND VGND VPWR VPWR sky130_fd_sc_hd__fill_2
XFILLER_0_69_486 VGND VGND VPWR VPWR sky130_fd_sc_hd__fill_1
XFILLER_0_56_147 VGND VGND VPWR VPWR sky130_fd_sc_hd__fill_1
XFILLER_0_84_489 VPWR VGND VPWR VGND sky130_ef_sc_hd__decap_12
XFILLER_0_37_350 VGND VGND VPWR VPWR sky130_fd_sc_hd__fill_1
XFILLER_0_44_309 VGND VGND VPWR VPWR sky130_fd_sc_hd__decap_6
XFILLER_0_69_47 VGND VGND VPWR VPWR sky130_fd_sc_hd__fill_1
X_3440_ _2041_ _2042_ _2025_ VGND VGND VPWR VPWR _2043_ sky130_fd_sc_hd__o21ai_1
X_3371_ _1413_ _1169_ _1414_ VGND VGND VPWR VPWR _1987_ sky130_fd_sc_hd__and3b_1
XTAP_935 VGND VPWR sky130_fd_sc_hd__tapvpwrvgnd_1
XTAP_924 VGND VPWR sky130_fd_sc_hd__tapvpwrvgnd_1
XTAP_913 VGND VPWR sky130_fd_sc_hd__tapvpwrvgnd_1
XTAP_902 VGND VPWR sky130_fd_sc_hd__tapvpwrvgnd_1
X_2322_ fifo1.mem\[1\]\[2\] _1203_ _1209_ VGND VGND VPWR VPWR _1210_ sky130_fd_sc_hd__o21ai_1
XTAP_968 VGND VPWR sky130_fd_sc_hd__tapvpwrvgnd_1
XTAP_957 VGND VPWR sky130_fd_sc_hd__tapvpwrvgnd_1
XTAP_946 VGND VPWR sky130_fd_sc_hd__tapvpwrvgnd_1
XTAP_979 VGND VPWR sky130_fd_sc_hd__tapvpwrvgnd_1
X_2253_ _0749_ _1143_ _1148_ VGND VGND VPWR VPWR _0250_ sky130_fd_sc_hd__o21ba_1
X_2184_ _1102_ _1117_ VGND VGND VPWR VPWR _1118_ sky130_fd_sc_hd__nor2_4
XFILLER_0_87_261 VPWR VGND VPWR VGND sky130_ef_sc_hd__decap_12
XFILLER_0_75_401 VGND VGND VPWR VPWR sky130_fd_sc_hd__decap_8
XFILLER_0_34_83 VGND VGND VPWR VPWR sky130_fd_sc_hd__fill_1
XFILLER_0_62_139 VGND VGND VPWR VPWR sky130_fd_sc_hd__fill_1
XFILLER_0_7_299 VGND VGND VPWR VPWR sky130_fd_sc_hd__decap_8
X_4756_ clknet_leaf_33_clock _0562_ VGND VGND VPWR VPWR fifo2.mem\[11\]\[2\] sky130_fd_sc_hd__dfxtp_1
X_4687_ clknet_leaf_32_clock _0493_ VGND VGND VPWR VPWR _0005_ sky130_fd_sc_hd__dfxtp_2
X_3707_ _0726_ _0727_ VGND VGND VPWR VPWR _0728_ sky130_fd_sc_hd__nand2_1
XFILLER_0_3_461 VPWR VGND VPWR VGND sky130_ef_sc_hd__decap_12
X_3638_ net42 _0671_ _0618_ net41 _0672_ VGND VGND VPWR VPWR _0673_ sky130_fd_sc_hd__o221ai_4
X_3569_ fifo1.rd_pointer\[2\] fifo1.wr_pointer\[2\] VGND VGND VPWR VPWR _0608_ sky130_fd_sc_hd__nor2_1
XFILLER_0_66_445 VGND VGND VPWR VPWR sky130_fd_sc_hd__decap_8
XFILLER_0_39_39 VGND VGND VPWR VPWR sky130_fd_sc_hd__decap_8
XTAP_209 VGND VPWR sky130_fd_sc_hd__tapvpwrvgnd_1
Xhold5 fifo1.mem\[12\]\[0\] VGND VGND VPWR VPWR net53 sky130_fd_sc_hd__dlygate4sd3_1
XFILLER_0_76_209 VGND VGND VPWR VPWR sky130_fd_sc_hd__fill_1
XFILLER_0_29_103 VGND VGND VPWR VPWR sky130_fd_sc_hd__fill_2
XFILLER_0_57_434 VGND VGND VPWR VPWR sky130_fd_sc_hd__decap_3
XFILLER_0_57_445 VGND VGND VPWR VPWR sky130_fd_sc_hd__decap_3
X_2940_ _1567_ fifo2.mem\[0\]\[4\] _1558_ VGND VGND VPWR VPWR _1644_ sky130_fd_sc_hd__o21ba_1
XFILLER_0_84_253 VPWR VGND VPWR VGND sky130_ef_sc_hd__decap_12
XFILLER_0_29_169 VGND VGND VPWR VPWR sky130_fd_sc_hd__fill_2
X_2871_ fifo2.mem\[13\]\[2\] _0004_ VGND VGND VPWR VPWR _1577_ sky130_fd_sc_hd__or2b_1
XFILLER_0_57_478 VPWR VGND VPWR VGND sky130_ef_sc_hd__decap_12
XFILLER_0_44_139 VGND VGND VPWR VPWR sky130_fd_sc_hd__fill_1
X_4610_ clknet_leaf_6_clock _0416_ VGND VGND VPWR VPWR fifo1.mem\[4\]\[3\] sky130_fd_sc_hd__dfxtp_1
XFILLER_0_72_459 VGND VGND VPWR VPWR sky130_fd_sc_hd__decap_4
XFILLER_0_4_203 VGND VGND VPWR VPWR sky130_fd_sc_hd__fill_1
X_4541_ clknet_leaf_15_clock _0347_ VGND VGND VPWR VPWR fifo1.mem\[12\]\[6\] sky130_fd_sc_hd__dfxtp_1
XFILLER_0_20_85 VPWR VGND VPWR VGND sky130_ef_sc_hd__decap_12
X_4472_ clknet_leaf_38_clock _0278_ VGND VGND VPWR VPWR fifo2.mem\[14\]\[0\] sky130_fd_sc_hd__dfxtp_1
X_3423_ fifo3.count\[1\] _2022_ _2027_ VGND VGND VPWR VPWR _2028_ sky130_fd_sc_hd__a21o_1
XFILLER_0_0_464 VPWR VGND VPWR VGND sky130_ef_sc_hd__decap_12
XTAP_710 VGND VPWR sky130_fd_sc_hd__tapvpwrvgnd_1
X_3354_ _0831_ _0784_ _0921_ VGND VGND VPWR VPWR _1978_ sky130_fd_sc_hd__a21oi_1
XTAP_721 VGND VPWR sky130_fd_sc_hd__tapvpwrvgnd_1
XTAP_732 VGND VPWR sky130_fd_sc_hd__tapvpwrvgnd_1
XTAP_743 VGND VPWR sky130_fd_sc_hd__tapvpwrvgnd_1
X_2305_ _1192_ _1185_ _0003_ VGND VGND VPWR VPWR _1193_ sky130_fd_sc_hd__a21oi_1
X_3285_ fifo3.mem\[7\]\[4\] _1838_ _1912_ VGND VGND VPWR VPWR _1913_ sky130_fd_sc_hd__o21ai_1
XTAP_754 VGND VPWR sky130_fd_sc_hd__tapvpwrvgnd_1
XTAP_765 VGND VPWR sky130_fd_sc_hd__tapvpwrvgnd_1
XTAP_776 VGND VPWR sky130_fd_sc_hd__tapvpwrvgnd_1
X_2236_ _1142_ VGND VGND VPWR VPWR _1143_ sky130_fd_sc_hd__clkbuf_4
XTAP_787 VGND VPWR sky130_fd_sc_hd__tapvpwrvgnd_1
XTAP_798 VGND VPWR sky130_fd_sc_hd__tapvpwrvgnd_1
XFILLER_0_17_3 VGND VGND VPWR VPWR sky130_fd_sc_hd__decap_4
X_2167_ _0712_ VGND VGND VPWR VPWR _1110_ sky130_fd_sc_hd__buf_4
XFILLER_0_48_489 VPWR VGND VPWR VGND sky130_ef_sc_hd__decap_12
XFILLER_0_90_245 VGND VGND VPWR VPWR sky130_fd_sc_hd__decap_6
XFILLER_0_90_289 VPWR VGND VPWR VGND sky130_ef_sc_hd__decap_12
X_4739_ clknet_leaf_52_clock _0545_ VGND VGND VPWR VPWR fifo3.count\[5\] sky130_fd_sc_hd__dfxtp_1
XFILLER_0_71_492 VGND VGND VPWR VPWR sky130_fd_sc_hd__decap_4
XFILLER_0_66_253 VPWR VGND VPWR VGND sky130_ef_sc_hd__decap_12
XFILLER_0_26_139 VGND VGND VPWR VPWR sky130_fd_sc_hd__fill_1
XFILLER_0_62_492 VPWR VGND VPWR VGND sky130_ef_sc_hd__decap_12
XFILLER_0_10_529 VGND VGND VPWR VPWR sky130_fd_sc_hd__decap_3
XFILLER_0_66_15 VGND VGND VPWR VPWR sky130_fd_sc_hd__decap_6
X_3070_ _0734_ _1754_ _1756_ _1757_ net99 VGND VGND VPWR VPWR _0458_ sky130_fd_sc_hd__a32o_1
XFILLER_0_15_52 VGND VGND VPWR VPWR sky130_fd_sc_hd__decap_4
XFILLER_0_15_85 VGND VGND VPWR VPWR sky130_fd_sc_hd__decap_3
X_3972_ _0916_ VGND VGND VPWR VPWR _0102_ sky130_fd_sc_hd__clkbuf_1
XFILLER_0_57_264 VPWR VGND VPWR VGND sky130_ef_sc_hd__decap_12
X_2923_ _1566_ _1568_ _1571_ _1573_ VGND VGND VPWR VPWR _1627_ sky130_fd_sc_hd__o22a_1
X_2854_ _1555_ _1557_ _1559_ VGND VGND VPWR VPWR _1560_ sky130_fd_sc_hd__a21oi_1
XFILLER_0_53_470 VGND VGND VPWR VPWR sky130_fd_sc_hd__decap_3
X_2785_ fifo2.soft_reset _0663_ _1503_ net11 VGND VGND VPWR VPWR _1504_ sky130_fd_sc_hd__and4b_2
X_4524_ clknet_leaf_24_clock _0330_ VGND VGND VPWR VPWR fifo2.mem\[4\]\[7\] sky130_fd_sc_hd__dfxtp_1
XFILLER_0_13_312 VGND VGND VPWR VPWR sky130_fd_sc_hd__decap_8
Xhold202 fifo2.mem\[12\]\[1\] VGND VGND VPWR VPWR net250 sky130_fd_sc_hd__dlygate4sd3_1
XFILLER_0_13_345 VGND VGND VPWR VPWR sky130_fd_sc_hd__fill_1
Xhold213 fifo3.mem\[15\]\[7\] VGND VGND VPWR VPWR net261 sky130_fd_sc_hd__dlygate4sd3_1
Xhold235 fifo2.mem\[11\]\[2\] VGND VGND VPWR VPWR net283 sky130_fd_sc_hd__dlygate4sd3_1
Xhold224 fifo1.mem\[14\]\[3\] VGND VGND VPWR VPWR net272 sky130_fd_sc_hd__dlygate4sd3_1
X_4455_ clknet_leaf_17_clock _0261_ VGND VGND VPWR VPWR fifo1.count\[3\] sky130_fd_sc_hd__dfxtp_1
Xhold268 fifo3.mem\[0\]\[0\] VGND VGND VPWR VPWR net316 sky130_fd_sc_hd__dlygate4sd3_1
XFILLER_0_40_186 VGND VGND VPWR VPWR sky130_fd_sc_hd__fill_2
Xhold257 fifo1.mem\[9\]\[3\] VGND VGND VPWR VPWR net305 sky130_fd_sc_hd__dlygate4sd3_1
Xhold246 fifo2.mem\[4\]\[3\] VGND VGND VPWR VPWR net294 sky130_fd_sc_hd__dlygate4sd3_1
XFILLER_0_0_272 VGND VGND VPWR VPWR sky130_fd_sc_hd__decap_8
X_3406_ fifo3.mem\[4\]\[8\] fifo3.mem\[5\]\[8\] fifo3.mem\[6\]\[8\] fifo3.mem\[7\]\[8\]
+ _1849_ _1893_ VGND VGND VPWR VPWR _2012_ sky130_fd_sc_hd__mux4_1
Xhold279 fifo2.mem\[8\]\[6\] VGND VGND VPWR VPWR net327 sky130_fd_sc_hd__dlygate4sd3_1
XFILLER_0_40_197 VGND VGND VPWR VPWR sky130_fd_sc_hd__decap_4
X_4386_ clknet_leaf_6_clock _0200_ VGND VGND VPWR VPWR fifo1.mem\[5\]\[6\] sky130_fd_sc_hd__dfxtp_1
X_3337_ _1960_ _1962_ _1827_ VGND VGND VPWR VPWR _1963_ sky130_fd_sc_hd__a21o_1
XTAP_540 VGND VPWR sky130_fd_sc_hd__tapvpwrvgnd_1
XTAP_551 VGND VPWR sky130_fd_sc_hd__tapvpwrvgnd_1
XTAP_562 VGND VPWR sky130_fd_sc_hd__tapvpwrvgnd_1
XTAP_573 VGND VPWR sky130_fd_sc_hd__tapvpwrvgnd_1
XTAP_584 VGND VPWR sky130_fd_sc_hd__tapvpwrvgnd_1
X_3268_ _1830_ fifo3.mem\[14\]\[4\] _1835_ VGND VGND VPWR VPWR _1896_ sky130_fd_sc_hd__o21a_1
XTAP_595 VGND VPWR sky130_fd_sc_hd__tapvpwrvgnd_1
X_3199_ _1828_ fifo3.mem\[10\]\[2\] _1806_ VGND VGND VPWR VPWR _1829_ sky130_fd_sc_hd__o21ai_1
X_2219_ _0797_ _1120_ _1125_ _1135_ VGND VGND VPWR VPWR _0229_ sky130_fd_sc_hd__a31o_1
XFILLER_0_48_231 VGND VGND VPWR VPWR sky130_fd_sc_hd__decap_3
XFILLER_0_36_448 VGND VGND VPWR VPWR sky130_fd_sc_hd__decap_8
XFILLER_0_6_3 VPWR VGND VPWR VGND sky130_ef_sc_hd__decap_12
XFILLER_0_36_29 VPWR VGND VPWR VGND sky130_ef_sc_hd__decap_12
XFILLER_0_67_540 VGND VGND VPWR VPWR sky130_fd_sc_hd__fill_1
XFILLER_0_27_459 VGND VGND VPWR VPWR sky130_fd_sc_hd__fill_1
X_2570_ _0744_ _1425_ _1429_ _1430_ net165 VGND VGND VPWR VPWR _0285_ sky130_fd_sc_hd__a32o_1
X_4240_ clknet_leaf_57_clock _0054_ VGND VGND VPWR VPWR fifo3.mem\[8\]\[1\] sky130_fd_sc_hd__dfxtp_1
X_4171_ regis.internal_parity\[5\] _1052_ _1053_ VGND VGND VPWR VPWR _0164_ sky130_fd_sc_hd__o21a_1
X_3122_ _0938_ _1771_ _1786_ VGND VGND VPWR VPWR _0481_ sky130_fd_sc_hd__a21o_1
X_3053_ net281 _1749_ _1751_ _0747_ VGND VGND VPWR VPWR _0447_ sky130_fd_sc_hd__a22o_1
XFILLER_0_77_326 VGND VGND VPWR VPWR sky130_fd_sc_hd__decap_8
X_3955_ _0907_ VGND VGND VPWR VPWR _0094_ sky130_fd_sc_hd__clkbuf_1
XFILLER_0_42_83 VGND VGND VPWR VPWR sky130_fd_sc_hd__fill_1
X_2906_ _1539_ fifo2.mem\[8\]\[3\] _1558_ VGND VGND VPWR VPWR _1611_ sky130_fd_sc_hd__o21ba_1
X_3886_ _0855_ _0856_ net310 _0857_ _0861_ VGND VGND VPWR VPWR _0071_ sky130_fd_sc_hd__a32o_1
XFILLER_0_60_204 VGND VGND VPWR VPWR sky130_fd_sc_hd__fill_2
XFILLER_0_84_3 VGND VGND VPWR VPWR sky130_fd_sc_hd__decap_4
XFILLER_0_5_364 VGND VGND VPWR VPWR sky130_fd_sc_hd__fill_1
X_2837_ _1541_ _1542_ VGND VGND VPWR VPWR _1543_ sky130_fd_sc_hd__nand2_1
XFILLER_0_13_142 VGND VGND VPWR VPWR sky130_fd_sc_hd__fill_2
X_2768_ _1107_ _1494_ _1495_ net111 VGND VGND VPWR VPWR _0418_ sky130_fd_sc_hd__a22o_1
X_4507_ clknet_leaf_38_clock _0313_ VGND VGND VPWR VPWR fifo2.mem\[10\]\[8\] sky130_fd_sc_hd__dfxtp_1
XFILLER_0_41_473 VGND VGND VPWR VPWR sky130_fd_sc_hd__fill_2
X_2699_ _0958_ _0957_ _1450_ _0719_ VGND VGND VPWR VPWR _1477_ sky130_fd_sc_hd__o31a_1
X_4438_ clknet_leaf_13_clock _0244_ VGND VGND VPWR VPWR fifo1.mem\[3\]\[5\] sky130_fd_sc_hd__dfxtp_1
XFILLER_0_6_83 VGND VGND VPWR VPWR sky130_fd_sc_hd__fill_1
X_4369_ clknet_leaf_51_clock _0183_ VGND VGND VPWR VPWR fifo2.mem\[15\]\[7\] sky130_fd_sc_hd__dfxtp_1
XTAP_370 VGND VPWR sky130_fd_sc_hd__tapvpwrvgnd_1
XTAP_381 VGND VPWR sky130_fd_sc_hd__tapvpwrvgnd_1
XTAP_392 VGND VPWR sky130_fd_sc_hd__tapvpwrvgnd_1
XPHY_21 VGND VGND VPWR VPWR sky130_fd_sc_hd__decap_3
XPHY_10 VGND VGND VPWR VPWR sky130_fd_sc_hd__decap_3
XPHY_32 VGND VGND VPWR VPWR sky130_fd_sc_hd__decap_3
XPHY_43 VGND VGND VPWR VPWR sky130_fd_sc_hd__decap_3
XPHY_54 VGND VGND VPWR VPWR sky130_fd_sc_hd__decap_3
XPHY_65 VGND VGND VPWR VPWR sky130_fd_sc_hd__decap_3
XFILLER_0_83_318 VPWR VGND VPWR VGND sky130_ef_sc_hd__decap_12
XPHY_76 VGND VGND VPWR VPWR sky130_fd_sc_hd__decap_3
XPHY_87 VGND VGND VPWR VPWR sky130_fd_sc_hd__decap_3
XPHY_98 VGND VGND VPWR VPWR sky130_fd_sc_hd__decap_3
XFILLER_0_64_521 VGND VGND VPWR VPWR sky130_fd_sc_hd__decap_8
XFILLER_0_91_373 VGND VGND VPWR VPWR sky130_fd_sc_hd__fill_1
XFILLER_0_67_370 VGND VGND VPWR VPWR sky130_fd_sc_hd__fill_1
XFILLER_0_12_20 VGND VGND VPWR VPWR sky130_fd_sc_hd__decap_8
XFILLER_0_27_223 VGND VGND VPWR VPWR sky130_fd_sc_hd__fill_1
X_3740_ fsm1.ld_state fsm1.laf_state fsm1.present_state\[1\] _0629_ VGND VGND VPWR
+ VPWR _0752_ sky130_fd_sc_hd__o31ai_4
X_3671_ _0697_ VGND VGND VPWR VPWR _0020_ sky130_fd_sc_hd__clkbuf_1
X_2622_ net291 _1437_ _1442_ _1444_ _0713_ VGND VGND VPWR VPWR _0323_ sky130_fd_sc_hd__a32o_1
X_2553_ _0744_ _1416_ _0837_ _1418_ net130 VGND VGND VPWR VPWR _0276_ sky130_fd_sc_hd__a32o_1
XFILLER_0_70_9 VGND VGND VPWR VPWR sky130_fd_sc_hd__fill_1
XFILLER_0_2_389 VPWR VGND VPWR VGND sky130_ef_sc_hd__decap_12
X_2484_ _1280_ _1185_ _1198_ VGND VGND VPWR VPWR _1367_ sky130_fd_sc_hd__a21o_1
X_4223_ clknet_leaf_11_clock _0037_ VGND VGND VPWR VPWR fifo1.mem\[0\]\[2\] sky130_fd_sc_hd__dfxtp_1
XFILLER_0_10_178 VPWR VGND VPWR VGND sky130_ef_sc_hd__decap_12
X_4154_ _0693_ VGND VGND VPWR VPWR _1042_ sky130_fd_sc_hd__clkbuf_4
X_3105_ _0925_ _1771_ _1776_ VGND VGND VPWR VPWR _0474_ sky130_fd_sc_hd__a21o_1
X_4085_ _0678_ _0681_ VGND VGND VPWR VPWR _0990_ sky130_fd_sc_hd__nand2_4
X_3036_ _1735_ _1736_ _1715_ _1693_ VGND VGND VPWR VPWR _1737_ sky130_fd_sc_hd__o22ai_1
XFILLER_0_77_189 VGND VGND VPWR VPWR sky130_fd_sc_hd__fill_1
X_3938_ net340 _0894_ VGND VGND VPWR VPWR _0090_ sky130_fd_sc_hd__nor2_1
XFILLER_0_18_245 VGND VGND VPWR VPWR sky130_fd_sc_hd__fill_1
X_3869_ _0763_ _0825_ _0830_ _0848_ VGND VGND VPWR VPWR _0067_ sky130_fd_sc_hd__a31o_1
XFILLER_0_41_281 VGND VGND VPWR VPWR sky130_fd_sc_hd__decap_6
XFILLER_0_68_145 VPWR VGND VPWR VGND sky130_ef_sc_hd__decap_12
XFILLER_0_49_381 VGND VGND VPWR VPWR sky130_fd_sc_hd__decap_3
XFILLER_0_24_215 VGND VGND VPWR VPWR sky130_fd_sc_hd__fill_1
XFILLER_0_64_395 VGND VGND VPWR VPWR sky130_fd_sc_hd__decap_8
XFILLER_0_74_37 VGND VGND VPWR VPWR sky130_fd_sc_hd__fill_1
XFILLER_0_59_145 VPWR VGND VPWR VGND sky130_ef_sc_hd__decap_12
XFILLER_0_59_167 VGND VGND VPWR VPWR sky130_fd_sc_hd__fill_1
X_4772_ clknet_leaf_60_clock _0578_ VGND VGND VPWR VPWR fifo3.mem\[11\]\[0\] sky130_fd_sc_hd__dfxtp_1
XFILLER_0_23_96 VGND VGND VPWR VPWR sky130_fd_sc_hd__decap_6
XFILLER_0_15_204 VPWR VGND VPWR VGND sky130_ef_sc_hd__decap_12
X_3723_ fifo1.data_in\[5\] VGND VGND VPWR VPWR _0739_ sky130_fd_sc_hd__buf_4
X_3654_ _0684_ _0685_ _0686_ _0654_ VGND VGND VPWR VPWR _0019_ sky130_fd_sc_hd__o31a_1
X_2605_ _1438_ _0859_ fifo1.data_in\[7\] _0860_ VGND VGND VPWR VPWR _1439_ sky130_fd_sc_hd__and4b_1
XFILLER_0_70_365 VGND VGND VPWR VPWR sky130_fd_sc_hd__fill_1
XFILLER_0_23_281 VPWR VGND VPWR VGND sky130_ef_sc_hd__decap_12
X_3585_ fifo2.rd_pointer\[1\] fifo2.wr_pointer\[1\] VGND VGND VPWR VPWR _0623_ sky130_fd_sc_hd__and2_1
X_2536_ fifo3.rd_pointer\[2\] fifo3.rd_pointer\[1\] _0637_ _1404_ fifo3.rd_pointer\[3\]
+ VGND VGND VPWR VPWR _1414_ sky130_fd_sc_hd__a41o_1
X_2467_ _1349_ _1325_ _1195_ _1350_ VGND VGND VPWR VPWR _1351_ sky130_fd_sc_hd__o211ai_1
X_4206_ clknet_leaf_24_clock _0020_ VGND VGND VPWR VPWR syn.count0\[0\] sky130_fd_sc_hd__dfxtp_2
XFILLER_0_47_3 VGND VGND VPWR VPWR sky130_fd_sc_hd__decap_8
X_2398_ _1227_ _1256_ _1282_ VGND VGND VPWR VPWR _1284_ sky130_fd_sc_hd__nand3_1
X_4137_ _1026_ _0680_ _0656_ regis.header_byte\[2\] VGND VGND VPWR VPWR _1032_ sky130_fd_sc_hd__a31o_1
X_4068_ _0737_ _0859_ _0972_ VGND VGND VPWR VPWR _0979_ sky130_fd_sc_hd__and3_1
X_3019_ _1554_ _1717_ _1720_ VGND VGND VPWR VPWR _0444_ sky130_fd_sc_hd__a21oi_1
XFILLER_0_19_521 VPWR VGND VPWR VGND sky130_ef_sc_hd__decap_12
XFILLER_0_61_321 VGND VGND VPWR VPWR sky130_fd_sc_hd__fill_1
XFILLER_0_6_470 VGND VGND VPWR VPWR sky130_fd_sc_hd__decap_6
XFILLER_0_61_387 VGND VGND VPWR VPWR sky130_fd_sc_hd__decap_4
XFILLER_0_14_270 VGND VGND VPWR VPWR sky130_fd_sc_hd__decap_4
XFILLER_0_44_29 VGND VGND VPWR VPWR sky130_fd_sc_hd__fill_1
XFILLER_0_56_126 VGND VGND VPWR VPWR sky130_fd_sc_hd__decap_3
XFILLER_0_8_29 VPWR VGND VPWR VGND sky130_ef_sc_hd__decap_12
X_3370_ _1986_ VGND VGND VPWR VPWR _0529_ sky130_fd_sc_hd__clkbuf_1
XTAP_925 VGND VPWR sky130_fd_sc_hd__tapvpwrvgnd_1
XTAP_914 VGND VPWR sky130_fd_sc_hd__tapvpwrvgnd_1
XTAP_903 VGND VPWR sky130_fd_sc_hd__tapvpwrvgnd_1
X_2321_ fifo1.mem\[0\]\[2\] _1188_ _1177_ VGND VGND VPWR VPWR _1209_ sky130_fd_sc_hd__o21ba_1
XTAP_958 VGND VPWR sky130_fd_sc_hd__tapvpwrvgnd_1
XTAP_947 VGND VPWR sky130_fd_sc_hd__tapvpwrvgnd_1
XTAP_936 VGND VPWR sky130_fd_sc_hd__tapvpwrvgnd_1
X_2252_ _0749_ _1122_ _1123_ _0757_ VGND VGND VPWR VPWR _1148_ sky130_fd_sc_hd__a31o_1
XTAP_969 VGND VPWR sky130_fd_sc_hd__tapvpwrvgnd_1
XFILLER_0_18_85 VGND VGND VPWR VPWR sky130_fd_sc_hd__decap_4
X_2183_ _1116_ VGND VGND VPWR VPWR _1117_ sky130_fd_sc_hd__clkbuf_4
XFILLER_0_87_273 VGND VGND VPWR VPWR sky130_fd_sc_hd__decap_6
XFILLER_0_7_201 VGND VGND VPWR VPWR sky130_fd_sc_hd__decap_6
X_4755_ clknet_leaf_41_clock _0561_ VGND VGND VPWR VPWR fifo2.mem\[11\]\[1\] sky130_fd_sc_hd__dfxtp_1
XFILLER_0_62_129 VGND VGND VPWR VPWR sky130_fd_sc_hd__fill_2
XFILLER_0_7_289 VGND VGND VPWR VPWR sky130_fd_sc_hd__decap_3
XFILLER_0_50_83 VGND VGND VPWR VPWR sky130_fd_sc_hd__fill_1
X_3706_ fifo2.wr_pointer\[0\] VGND VGND VPWR VPWR _0727_ sky130_fd_sc_hd__clkbuf_4
XFILLER_0_31_505 VPWR VGND VPWR VGND sky130_ef_sc_hd__decap_12
X_4686_ clknet_leaf_32_clock _0492_ VGND VGND VPWR VPWR _0004_ sky130_fd_sc_hd__dfxtp_2
X_3637_ fsm1.addr\[1\] fsm1.addr\[0\] _0617_ VGND VGND VPWR VPWR _0672_ sky130_fd_sc_hd__or3_1
XFILLER_0_3_473 VPWR VGND VPWR VGND sky130_ef_sc_hd__decap_12
X_3568_ fifo1.rd_pointer\[1\] fifo1.wr_pointer\[1\] VGND VGND VPWR VPWR _0607_ sky130_fd_sc_hd__and2_1
XFILLER_0_11_273 VGND VGND VPWR VPWR sky130_fd_sc_hd__fill_1
X_2519_ fifo3.count\[4\] fifo3.count\[3\] VGND VGND VPWR VPWR _1400_ sky130_fd_sc_hd__nor2_1
X_3499_ _0733_ _0746_ _0871_ _2081_ net283 VGND VGND VPWR VPWR _0562_ sky130_fd_sc_hd__a32o_1
Xclkbuf_leaf_44_clock clknet_3_5__leaf_clock VGND VGND VPWR VPWR clknet_leaf_44_clock
+ sky130_fd_sc_hd__clkbuf_16
Xclkbuf_leaf_59_clock clknet_3_0__leaf_clock VGND VGND VPWR VPWR clknet_leaf_59_clock
+ sky130_fd_sc_hd__clkbuf_16
XFILLER_0_38_115 VGND VGND VPWR VPWR sky130_fd_sc_hd__fill_2
XFILLER_0_81_405 VPWR VGND VPWR VGND sky130_ef_sc_hd__decap_12
XFILLER_0_22_505 VPWR VGND VPWR VGND sky130_ef_sc_hd__decap_12
XFILLER_0_34_376 VPWR VGND VPWR VGND sky130_ef_sc_hd__decap_12
XFILLER_0_89_505 VPWR VGND VPWR VGND sky130_ef_sc_hd__decap_12
Xhold6 fifo3.mem\[14\]\[8\] VGND VGND VPWR VPWR net54 sky130_fd_sc_hd__dlygate4sd3_1
XFILLER_0_55_39 VGND VGND VPWR VPWR sky130_fd_sc_hd__decap_6
XFILLER_0_69_262 VPWR VGND VPWR VGND sky130_ef_sc_hd__decap_12
XFILLER_0_84_265 VPWR VGND VPWR VGND sky130_ef_sc_hd__decap_12
X_2870_ _0004_ fifo2.mem\[12\]\[2\] _0005_ VGND VGND VPWR VPWR _1576_ sky130_fd_sc_hd__o21ba_1
X_4540_ clknet_leaf_16_clock _0346_ VGND VGND VPWR VPWR fifo1.mem\[12\]\[5\] sky130_fd_sc_hd__dfxtp_1
XFILLER_0_80_471 VGND VGND VPWR VPWR sky130_fd_sc_hd__decap_4
XFILLER_0_13_505 VPWR VGND VPWR VGND sky130_ef_sc_hd__decap_12
XFILLER_0_4_259 VGND VGND VPWR VPWR sky130_fd_sc_hd__decap_6
X_4471_ clknet_leaf_3_clock _0277_ VGND VGND VPWR VPWR fifo3.mem\[3\]\[8\] sky130_fd_sc_hd__dfxtp_1
XFILLER_0_0_421 VPWR VGND VPWR VGND sky130_ef_sc_hd__decap_12
XFILLER_0_20_97 VGND VGND VPWR VPWR sky130_fd_sc_hd__decap_4
X_3422_ fifo3.count\[1\] _2022_ _2025_ VGND VGND VPWR VPWR _2027_ sky130_fd_sc_hd__o21ai_1
XTAP_700 VGND VPWR sky130_fd_sc_hd__tapvpwrvgnd_1
X_3353_ _1977_ VGND VGND VPWR VPWR _0521_ sky130_fd_sc_hd__clkbuf_1
XTAP_711 VGND VPWR sky130_fd_sc_hd__tapvpwrvgnd_1
XTAP_722 VGND VPWR sky130_fd_sc_hd__tapvpwrvgnd_1
XTAP_733 VGND VPWR sky130_fd_sc_hd__tapvpwrvgnd_1
X_3284_ _0008_ fifo3.mem\[6\]\[4\] _1841_ VGND VGND VPWR VPWR _1912_ sky130_fd_sc_hd__o21a_1
X_2304_ fifo1.mem\[4\]\[8\] fifo1.mem\[5\]\[8\] fifo1.mem\[6\]\[8\] fifo1.mem\[7\]\[8\]
+ _1176_ _1178_ VGND VGND VPWR VPWR _1192_ sky130_fd_sc_hd__mux4_2
XTAP_744 VGND VPWR sky130_fd_sc_hd__tapvpwrvgnd_1
XTAP_755 VGND VPWR sky130_fd_sc_hd__tapvpwrvgnd_1
XTAP_766 VGND VPWR sky130_fd_sc_hd__tapvpwrvgnd_1
XTAP_777 VGND VPWR sky130_fd_sc_hd__tapvpwrvgnd_1
X_2235_ fifo1.wr_pointer\[1\] fifo1.wr_pointer\[0\] _1111_ VGND VGND VPWR VPWR _1142_
+ sky130_fd_sc_hd__and3_1
XTAP_788 VGND VPWR sky130_fd_sc_hd__tapvpwrvgnd_1
XTAP_799 VGND VPWR sky130_fd_sc_hd__tapvpwrvgnd_1
X_2166_ _0768_ _1101_ _1103_ net211 VGND VGND VPWR VPWR _0202_ sky130_fd_sc_hd__a22o_1
XFILLER_0_45_94 VGND VGND VPWR VPWR sky130_fd_sc_hd__fill_2
XFILLER_0_75_243 VGND VGND VPWR VPWR sky130_fd_sc_hd__fill_1
XFILLER_0_8_521 VGND VGND VPWR VPWR sky130_fd_sc_hd__decap_8
XFILLER_0_0_85 VGND VGND VPWR VPWR sky130_fd_sc_hd__decap_6
X_2999_ _1547_ _1700_ _1538_ VGND VGND VPWR VPWR _1701_ sky130_fd_sc_hd__a21oi_1
X_4738_ clknet_leaf_52_clock _0544_ VGND VGND VPWR VPWR fifo3.count\[4\] sky130_fd_sc_hd__dfxtp_1
X_4669_ clknet_leaf_58_clock _0475_ VGND VGND VPWR VPWR fifo3.mem\[9\]\[1\] sky130_fd_sc_hd__dfxtp_1
XFILLER_0_31_335 VGND VGND VPWR VPWR sky130_fd_sc_hd__fill_1
XFILLER_0_3_281 VGND VGND VPWR VPWR sky130_fd_sc_hd__decap_4
XFILLER_0_26_129 VGND VGND VPWR VPWR sky130_fd_sc_hd__fill_1
XFILLER_0_66_265 VPWR VGND VPWR VGND sky130_ef_sc_hd__decap_12
XFILLER_0_81_279 VGND VGND VPWR VPWR sky130_fd_sc_hd__fill_1
XFILLER_0_89_335 VGND VGND VPWR VPWR sky130_fd_sc_hd__fill_1
X_3971_ net6 regis.fifo_full_state\[5\] _0910_ VGND VGND VPWR VPWR _0916_ sky130_fd_sc_hd__mux2_1
X_2922_ _1547_ _1580_ _1625_ VGND VGND VPWR VPWR _1626_ sky130_fd_sc_hd__o21ai_1
XFILLER_0_72_213 VGND VGND VPWR VPWR sky130_fd_sc_hd__fill_1
XFILLER_0_17_107 VGND VGND VPWR VPWR sky130_fd_sc_hd__decap_4
XFILLER_0_57_276 VGND VGND VPWR VPWR sky130_fd_sc_hd__decap_4
XFILLER_0_5_502 VGND VGND VPWR VPWR sky130_fd_sc_hd__fill_2
X_2853_ _1539_ fifo2.mem\[4\]\[2\] _1558_ VGND VGND VPWR VPWR _1559_ sky130_fd_sc_hd__o21bai_1
X_2784_ fifo2.count\[6\] fifo2.count\[5\] _1501_ _1502_ VGND VGND VPWR VPWR _1503_
+ sky130_fd_sc_hd__or4bb_1
X_4523_ clknet_leaf_24_clock _0329_ VGND VGND VPWR VPWR fifo2.mem\[4\]\[6\] sky130_fd_sc_hd__dfxtp_1
Xhold203 fifo1.mem\[14\]\[6\] VGND VGND VPWR VPWR net251 sky130_fd_sc_hd__dlygate4sd3_1
Xhold214 fifo3.mem\[15\]\[6\] VGND VGND VPWR VPWR net262 sky130_fd_sc_hd__dlygate4sd3_1
Xhold225 fifo3.mem\[0\]\[5\] VGND VGND VPWR VPWR net273 sky130_fd_sc_hd__dlygate4sd3_1
Xhold236 fifo1.mem\[15\]\[1\] VGND VGND VPWR VPWR net284 sky130_fd_sc_hd__dlygate4sd3_1
X_4454_ clknet_leaf_17_clock _0260_ VGND VGND VPWR VPWR fifo1.count\[2\] sky130_fd_sc_hd__dfxtp_1
Xhold269 fifo2.mem\[4\]\[6\] VGND VGND VPWR VPWR net317 sky130_fd_sc_hd__dlygate4sd3_1
Xhold258 fifo3.mem\[3\]\[3\] VGND VGND VPWR VPWR net306 sky130_fd_sc_hd__dlygate4sd3_1
Xhold247 fifo2.mem\[12\]\[2\] VGND VGND VPWR VPWR net295 sky130_fd_sc_hd__dlygate4sd3_1
X_3405_ _1812_ _2010_ VGND VGND VPWR VPWR _2011_ sky130_fd_sc_hd__nand2_1
X_4385_ clknet_leaf_7_clock _0199_ VGND VGND VPWR VPWR fifo1.mem\[5\]\[5\] sky130_fd_sc_hd__dfxtp_1
X_3336_ fifo3.mem\[3\]\[6\] _1942_ _1961_ VGND VGND VPWR VPWR _1962_ sky130_fd_sc_hd__o21ai_1
XTAP_530 VGND VPWR sky130_fd_sc_hd__tapvpwrvgnd_1
XTAP_541 VGND VPWR sky130_fd_sc_hd__tapvpwrvgnd_1
XTAP_552 VGND VPWR sky130_fd_sc_hd__tapvpwrvgnd_1
XTAP_563 VGND VPWR sky130_fd_sc_hd__tapvpwrvgnd_1
XTAP_574 VGND VPWR sky130_fd_sc_hd__tapvpwrvgnd_1
XTAP_585 VGND VPWR sky130_fd_sc_hd__tapvpwrvgnd_1
X_3267_ _1832_ fifo3.mem\[12\]\[4\] VGND VGND VPWR VPWR _1895_ sky130_fd_sc_hd__nor2_1
XTAP_596 VGND VPWR sky130_fd_sc_hd__tapvpwrvgnd_1
XFILLER_0_56_82 VGND VGND VPWR VPWR sky130_fd_sc_hd__fill_2
X_3198_ _0008_ VGND VGND VPWR VPWR _1828_ sky130_fd_sc_hd__buf_4
X_2218_ _1126_ _1119_ fifo1.mem\[7\]\[8\] VGND VGND VPWR VPWR _1135_ sky130_fd_sc_hd__and3_1
X_2149_ _1100_ VGND VGND VPWR VPWR _1101_ sky130_fd_sc_hd__clkbuf_4
XFILLER_0_91_533 VGND VGND VPWR VPWR sky130_fd_sc_hd__fill_2
XFILLER_0_86_327 VPWR VGND VPWR VGND sky130_ef_sc_hd__decap_12
XFILLER_0_27_427 VGND VGND VPWR VPWR sky130_fd_sc_hd__fill_1
XFILLER_0_82_533 VGND VGND VPWR VPWR sky130_fd_sc_hd__decap_8
XFILLER_0_27_449 VGND VGND VPWR VPWR sky130_fd_sc_hd__decap_4
XFILLER_0_54_235 VPWR VGND VPWR VGND sky130_ef_sc_hd__decap_12
XFILLER_0_50_463 VGND VGND VPWR VPWR sky130_fd_sc_hd__fill_1
XFILLER_0_77_48 VGND VGND VPWR VPWR sky130_fd_sc_hd__fill_1
X_4170_ _1052_ regis.internal_parity\[5\] _1042_ VGND VGND VPWR VPWR _1053_ sky130_fd_sc_hd__a21boi_1
X_3121_ _0839_ _1779_ _1781_ fifo3.mem\[9\]\[7\] _1783_ VGND VGND VPWR VPWR _1786_
+ sky130_fd_sc_hd__o311a_1
X_3052_ _1750_ VGND VGND VPWR VPWR _1751_ sky130_fd_sc_hd__buf_2
XFILLER_0_26_85 VGND VGND VPWR VPWR sky130_fd_sc_hd__decap_3
XFILLER_0_9_148 VGND VGND VPWR VPWR sky130_fd_sc_hd__fill_2
X_3954_ _0898_ _0905_ _0906_ VGND VGND VPWR VPWR _0907_ sky130_fd_sc_hd__and3_1
XFILLER_0_85_393 VPWR VGND VPWR VGND sky130_ef_sc_hd__decap_12
XFILLER_0_73_522 VGND VGND VPWR VPWR sky130_fd_sc_hd__fill_1
X_3885_ _0725_ _0859_ fifo1.data_in\[0\] _0860_ VGND VGND VPWR VPWR _0861_ sky130_fd_sc_hd__and4b_1
X_2905_ _1609_ _1542_ _1537_ VGND VGND VPWR VPWR _1610_ sky130_fd_sc_hd__a21oi_2
X_2836_ _0006_ VGND VGND VPWR VPWR _1542_ sky130_fd_sc_hd__clkbuf_4
XFILLER_0_26_460 VGND VGND VPWR VPWR sky130_fd_sc_hd__decap_4
XFILLER_0_41_430 VGND VGND VPWR VPWR sky130_fd_sc_hd__fill_2
X_2767_ _1106_ _1494_ _1495_ net115 VGND VGND VPWR VPWR _0417_ sky130_fd_sc_hd__a22o_1
X_2698_ _0797_ _0724_ _1436_ _1476_ VGND VGND VPWR VPWR _0367_ sky130_fd_sc_hd__a31o_1
XFILLER_0_77_3 VGND VGND VPWR VPWR sky130_fd_sc_hd__fill_1
X_4506_ clknet_leaf_38_clock _0312_ VGND VGND VPWR VPWR fifo2.mem\[10\]\[7\] sky130_fd_sc_hd__dfxtp_1
X_4437_ clknet_leaf_11_clock _0243_ VGND VGND VPWR VPWR fifo1.mem\[3\]\[4\] sky130_fd_sc_hd__dfxtp_1
XTAP_360 VGND VPWR sky130_fd_sc_hd__tapvpwrvgnd_1
X_4368_ clknet_leaf_51_clock _0182_ VGND VGND VPWR VPWR fifo2.mem\[15\]\[6\] sky130_fd_sc_hd__dfxtp_1
X_3319_ _1864_ fifo3.mem\[10\]\[6\] _1893_ VGND VGND VPWR VPWR _1945_ sky130_fd_sc_hd__o21a_1
XTAP_371 VGND VPWR sky130_fd_sc_hd__tapvpwrvgnd_1
XTAP_382 VGND VPWR sky130_fd_sc_hd__tapvpwrvgnd_1
XTAP_393 VGND VPWR sky130_fd_sc_hd__tapvpwrvgnd_1
X_4299_ clknet_leaf_0_clock _0113_ VGND VGND VPWR VPWR fifo3.mem\[5\]\[8\] sky130_fd_sc_hd__dfxtp_1
XPHY_22 VGND VGND VPWR VPWR sky130_fd_sc_hd__decap_3
XPHY_11 VGND VGND VPWR VPWR sky130_fd_sc_hd__decap_3
XPHY_33 VGND VGND VPWR VPWR sky130_fd_sc_hd__decap_3
XPHY_44 VGND VGND VPWR VPWR sky130_fd_sc_hd__decap_3
XPHY_55 VGND VGND VPWR VPWR sky130_fd_sc_hd__decap_3
XFILLER_0_49_530 VGND VGND VPWR VPWR sky130_fd_sc_hd__decap_8
XFILLER_0_76_371 VGND VGND VPWR VPWR sky130_fd_sc_hd__decap_8
XPHY_66 VGND VGND VPWR VPWR sky130_fd_sc_hd__decap_3
XPHY_77 VGND VGND VPWR VPWR sky130_fd_sc_hd__decap_3
XPHY_88 VGND VGND VPWR VPWR sky130_fd_sc_hd__decap_3
XFILLER_0_36_213 VGND VGND VPWR VPWR sky130_fd_sc_hd__fill_1
XPHY_99 VGND VGND VPWR VPWR sky130_fd_sc_hd__decap_3
XFILLER_0_64_533 VGND VGND VPWR VPWR sky130_fd_sc_hd__decap_8
XFILLER_0_36_246 VGND VGND VPWR VPWR sky130_fd_sc_hd__fill_2
XFILLER_0_17_471 VGND VGND VPWR VPWR sky130_fd_sc_hd__decap_3
XFILLER_0_86_135 VGND VGND VPWR VPWR sky130_fd_sc_hd__decap_4
XFILLER_0_55_500 VGND VGND VPWR VPWR sky130_fd_sc_hd__decap_4
XFILLER_0_27_235 VGND VGND VPWR VPWR sky130_fd_sc_hd__decap_8
XFILLER_0_82_363 VGND VGND VPWR VPWR sky130_fd_sc_hd__fill_1
X_3670_ syn.count0\[0\] net40 _0694_ _0696_ VGND VGND VPWR VPWR _0697_ sky130_fd_sc_hd__and4b_1
XFILLER_0_27_279 VGND VGND VPWR VPWR sky130_fd_sc_hd__fill_1
X_2621_ _1443_ VGND VGND VPWR VPWR _1444_ sky130_fd_sc_hd__buf_2
X_2552_ _0764_ _1416_ _0830_ _1422_ VGND VGND VPWR VPWR _0275_ sky130_fd_sc_hd__a31o_1
X_4222_ clknet_leaf_13_clock _0036_ VGND VGND VPWR VPWR fifo1.mem\[0\]\[1\] sky130_fd_sc_hd__dfxtp_1
X_2483_ _1272_ _1274_ _1200_ VGND VGND VPWR VPWR _1366_ sky130_fd_sc_hd__a21oi_1
X_4153_ regis.header_byte\[0\] _0690_ _1040_ _0659_ VGND VGND VPWR VPWR _1041_ sky130_fd_sc_hd__a22o_1
X_3104_ _0839_ _1772_ _1774_ fifo3.mem\[9\]\[0\] _1775_ VGND VGND VPWR VPWR _1776_
+ sky130_fd_sc_hd__o311a_1
X_4084_ _0988_ VGND VGND VPWR VPWR _0989_ sky130_fd_sc_hd__buf_2
X_3035_ _1732_ _1730_ VGND VGND VPWR VPWR _1736_ sky130_fd_sc_hd__and2_1
XFILLER_0_53_83 VGND VGND VPWR VPWR sky130_fd_sc_hd__fill_2
XFILLER_0_58_360 VGND VGND VPWR VPWR sky130_fd_sc_hd__decap_4
X_3937_ net12 net42 _0652_ VGND VGND VPWR VPWR _0894_ sky130_fd_sc_hd__nand3b_4
XFILLER_0_46_533 VGND VGND VPWR VPWR sky130_fd_sc_hd__decap_8
X_3868_ _0832_ _0840_ _0841_ _0844_ fifo3.mem\[1\]\[5\] VGND VGND VPWR VPWR _0848_
+ sky130_fd_sc_hd__o311a_1
X_2819_ _1526_ _1528_ _1198_ _1531_ _0875_ VGND VGND VPWR VPWR _0433_ sky130_fd_sc_hd__o221a_1
X_3799_ _0764_ _0778_ _0790_ _0795_ VGND VGND VPWR VPWR _0050_ sky130_fd_sc_hd__a31o_1
XFILLER_0_5_184 VGND VGND VPWR VPWR sky130_fd_sc_hd__decap_4
XFILLER_0_78_91 VGND VGND VPWR VPWR sky130_fd_sc_hd__decap_8
XTAP_190 VGND VPWR sky130_fd_sc_hd__tapvpwrvgnd_1
XFILLER_0_68_157 VGND VGND VPWR VPWR sky130_fd_sc_hd__fill_2
XFILLER_0_49_393 VGND VGND VPWR VPWR sky130_fd_sc_hd__decap_3
Xclkbuf_3_0__f_clock clknet_0_clock VGND VGND VPWR VPWR clknet_3_0__leaf_clock sky130_fd_sc_hd__clkbuf_16
XFILLER_0_32_271 VGND VGND VPWR VPWR sky130_fd_sc_hd__decap_6
XFILLER_0_58_39 VGND VGND VPWR VPWR sky130_fd_sc_hd__decap_3
XFILLER_0_59_113 VGND VGND VPWR VPWR sky130_fd_sc_hd__decap_6
XFILLER_0_47_308 VGND VGND VPWR VPWR sky130_fd_sc_hd__fill_1
XFILLER_0_59_157 VGND VGND VPWR VPWR sky130_fd_sc_hd__decap_4
XFILLER_0_28_533 VGND VGND VPWR VPWR sky130_fd_sc_hd__decap_8
X_4771_ clknet_leaf_59_clock _0577_ VGND VGND VPWR VPWR fifo3.mem\[10\]\[8\] sky130_fd_sc_hd__dfxtp_1
XFILLER_0_7_449 VGND VGND VPWR VPWR sky130_fd_sc_hd__decap_4
XFILLER_0_55_330 VGND VGND VPWR VPWR sky130_fd_sc_hd__decap_6
XFILLER_0_55_341 VPWR VGND VPWR VGND sky130_ef_sc_hd__decap_12
XFILLER_0_15_216 VGND VGND VPWR VPWR sky130_fd_sc_hd__decap_4
XFILLER_0_43_503 VGND VGND VPWR VPWR sky130_fd_sc_hd__fill_1
X_3722_ _0738_ _0715_ _0724_ _0730_ net157 VGND VGND VPWR VPWR _0030_ sky130_fd_sc_hd__a32o_1
XFILLER_0_82_193 VGND VGND VPWR VPWR sky130_fd_sc_hd__decap_3
X_3653_ fsm1.parity_done _0677_ _0682_ VGND VGND VPWR VPWR _0686_ sky130_fd_sc_hd__nor3_1
X_2604_ _0716_ VGND VGND VPWR VPWR _1438_ sky130_fd_sc_hd__clkbuf_4
XFILLER_0_23_293 VGND VGND VPWR VPWR sky130_fd_sc_hd__decap_8
X_3584_ fifo2.rd_pointer\[1\] fifo2.wr_pointer\[1\] VGND VGND VPWR VPWR _0622_ sky130_fd_sc_hd__nor2_1
XFILLER_0_11_455 VGND VGND VPWR VPWR sky130_fd_sc_hd__decap_4
XFILLER_0_2_176 VGND VGND VPWR VPWR sky130_fd_sc_hd__fill_1
X_2535_ fifo3.rd_pointer\[1\] _0637_ _1404_ _1412_ VGND VGND VPWR VPWR _1413_ sky130_fd_sc_hd__and4_1
X_2466_ _1325_ _1349_ VGND VGND VPWR VPWR _1350_ sky130_fd_sc_hd__nand2_1
XFILLER_0_11_488 VGND VGND VPWR VPWR sky130_fd_sc_hd__fill_2
X_4205_ _1070_ _1071_ _1076_ VGND VGND VPWR VPWR _1077_ sky130_fd_sc_hd__a21o_1
X_2397_ _1227_ _1256_ _1282_ VGND VGND VPWR VPWR _1283_ sky130_fd_sc_hd__a21oi_1
X_4136_ _1031_ VGND VGND VPWR VPWR _0151_ sky130_fd_sc_hd__clkbuf_1
X_4067_ _0976_ _0867_ fifo2.mem\[0\]\[3\] net47 _0978_ VGND VGND VPWR VPWR _0135_
+ sky130_fd_sc_hd__a32o_1
X_3018_ _1718_ _1554_ _1719_ _0963_ VGND VGND VPWR VPWR _1720_ sky130_fd_sc_hd__o31ai_1
XFILLER_0_78_477 VPWR VGND VPWR VGND sky130_ef_sc_hd__decap_12
XFILLER_0_19_533 VGND VGND VPWR VPWR sky130_fd_sc_hd__decap_8
XFILLER_0_46_385 VPWR VGND VPWR VGND sky130_ef_sc_hd__decap_12
XFILLER_0_61_333 VGND VGND VPWR VPWR sky130_fd_sc_hd__decap_3
XFILLER_0_61_344 VGND VGND VPWR VPWR sky130_fd_sc_hd__fill_2
XFILLER_0_14_260 VGND VGND VPWR VPWR sky130_fd_sc_hd__fill_2
XFILLER_0_69_466 VGND VGND VPWR VPWR sky130_fd_sc_hd__fill_1
XFILLER_0_37_330 VGND VGND VPWR VPWR sky130_fd_sc_hd__decap_6
XFILLER_0_25_503 VGND VGND VPWR VPWR sky130_fd_sc_hd__fill_1
XFILLER_0_71_108 VGND VGND VPWR VPWR sky130_fd_sc_hd__decap_4
XFILLER_0_4_419 VGND VGND VPWR VPWR sky130_fd_sc_hd__fill_1
XFILLER_0_85_15 VGND VGND VPWR VPWR sky130_fd_sc_hd__fill_1
XTAP_926 VGND VPWR sky130_fd_sc_hd__tapvpwrvgnd_1
XTAP_915 VGND VPWR sky130_fd_sc_hd__tapvpwrvgnd_1
XTAP_904 VGND VPWR sky130_fd_sc_hd__tapvpwrvgnd_1
X_2320_ _1205_ _1207_ _1175_ VGND VGND VPWR VPWR _1208_ sky130_fd_sc_hd__a21o_1
XTAP_959 VGND VPWR sky130_fd_sc_hd__tapvpwrvgnd_1
XTAP_948 VGND VPWR sky130_fd_sc_hd__tapvpwrvgnd_1
XTAP_937 VGND VPWR sky130_fd_sc_hd__tapvpwrvgnd_1
X_2251_ _1147_ VGND VGND VPWR VPWR _0249_ sky130_fd_sc_hd__clkbuf_1
X_2182_ _0748_ _0751_ _0753_ _1094_ VGND VGND VPWR VPWR _1116_ sky130_fd_sc_hd__and4b_1
XFILLER_0_34_41 VGND VGND VPWR VPWR sky130_fd_sc_hd__decap_4
XFILLER_0_75_447 VGND VGND VPWR VPWR sky130_fd_sc_hd__fill_1
XFILLER_0_34_85 VGND VGND VPWR VPWR sky130_fd_sc_hd__decap_4
XFILLER_0_90_428 VPWR VGND VPWR VGND sky130_ef_sc_hd__decap_12
X_4754_ clknet_leaf_40_clock _0560_ VGND VGND VPWR VPWR fifo2.mem\[11\]\[0\] sky130_fd_sc_hd__dfxtp_1
X_3705_ fifo2.wr_pointer\[1\] VGND VGND VPWR VPWR _0726_ sky130_fd_sc_hd__clkbuf_4
X_4685_ clknet_leaf_62_clock _0491_ VGND VGND VPWR VPWR fifo3.mem\[4\]\[8\] sky130_fd_sc_hd__dfxtp_1
XFILLER_0_31_517 VPWR VGND VPWR VGND sky130_ef_sc_hd__decap_12
XFILLER_0_3_441 VGND VGND VPWR VPWR sky130_fd_sc_hd__decap_6
X_3636_ fsm1.addr\[0\] fsm1.addr\[1\] VGND VGND VPWR VPWR _0671_ sky130_fd_sc_hd__or2b_1
XFILLER_0_43_388 VGND VGND VPWR VPWR sky130_fd_sc_hd__decap_4
XFILLER_0_3_485 VPWR VGND VPWR VGND sky130_ef_sc_hd__decap_12
X_3567_ fifo1.rd_pointer\[1\] fifo1.wr_pointer\[1\] VGND VGND VPWR VPWR _0606_ sky130_fd_sc_hd__nor2_1
X_2518_ fifo3.count\[2\] fifo3.count\[1\] fifo3.count\[0\] VGND VGND VPWR VPWR _1399_
+ sky130_fd_sc_hd__nor3_1
XFILLER_0_59_93 VGND VGND VPWR VPWR sky130_fd_sc_hd__fill_1
X_3498_ _2082_ _0963_ fifo2.mem\[11\]\[1\] _0715_ _0862_ VGND VGND VPWR VPWR _0561_
+ sky130_fd_sc_hd__a32o_1
X_2449_ _1295_ fifo1.mem\[14\]\[6\] _1183_ VGND VGND VPWR VPWR _1333_ sky130_fd_sc_hd__o21a_1
X_4119_ regis.fifo_full_state\[6\] _0990_ _0690_ VGND VGND VPWR VPWR _1018_ sky130_fd_sc_hd__o21ba_1
XFILLER_0_81_417 VPWR VGND VPWR VGND sky130_ef_sc_hd__decap_12
XFILLER_0_22_517 VPWR VGND VPWR VGND sky130_ef_sc_hd__decap_12
XFILLER_0_34_388 VGND VGND VPWR VPWR sky130_fd_sc_hd__fill_2
Xhold7 fifo1.mem\[5\]\[6\] VGND VGND VPWR VPWR net55 sky130_fd_sc_hd__dlygate4sd3_1
XFILLER_0_89_517 VPWR VGND VPWR VGND sky130_ef_sc_hd__decap_12
XFILLER_0_69_241 VGND VGND VPWR VPWR sky130_fd_sc_hd__fill_1
XFILLER_0_29_127 VGND VGND VPWR VPWR sky130_fd_sc_hd__decap_4
XFILLER_0_69_274 VGND VGND VPWR VPWR sky130_fd_sc_hd__decap_6
XFILLER_0_84_244 VGND VGND VPWR VPWR sky130_fd_sc_hd__decap_8
XFILLER_0_29_149 VGND VGND VPWR VPWR sky130_fd_sc_hd__fill_1
XFILLER_0_57_469 VGND VGND VPWR VPWR sky130_fd_sc_hd__fill_1
XFILLER_0_84_277 VGND VGND VPWR VPWR sky130_fd_sc_hd__decap_3
XFILLER_0_13_517 VPWR VGND VPWR VGND sky130_ef_sc_hd__decap_12
XFILLER_0_52_141 VGND VGND VPWR VPWR sky130_fd_sc_hd__decap_6
X_4470_ clknet_leaf_4_clock _0276_ VGND VGND VPWR VPWR fifo3.mem\[3\]\[7\] sky130_fd_sc_hd__dfxtp_1
X_3421_ _2019_ _2021_ _2022_ _2026_ VGND VGND VPWR VPWR _0540_ sky130_fd_sc_hd__o31a_1
XFILLER_0_0_433 VPWR VGND VPWR VGND sky130_ef_sc_hd__decap_12
X_3352_ _1976_ _1042_ VGND VGND VPWR VPWR _1977_ sky130_fd_sc_hd__and2_1
XTAP_701 VGND VPWR sky130_fd_sc_hd__tapvpwrvgnd_1
X_2303_ _1187_ _1190_ VGND VGND VPWR VPWR _1191_ sky130_fd_sc_hd__nand2_1
XFILLER_0_0_477 VPWR VGND VPWR VGND sky130_ef_sc_hd__decap_12
XTAP_712 VGND VPWR sky130_fd_sc_hd__tapvpwrvgnd_1
XTAP_723 VGND VPWR sky130_fd_sc_hd__tapvpwrvgnd_1
XTAP_734 VGND VPWR sky130_fd_sc_hd__tapvpwrvgnd_1
X_3283_ _1838_ fifo3.mem\[5\]\[4\] _1910_ VGND VGND VPWR VPWR _1911_ sky130_fd_sc_hd__o21ai_1
XTAP_745 VGND VPWR sky130_fd_sc_hd__tapvpwrvgnd_1
XTAP_756 VGND VPWR sky130_fd_sc_hd__tapvpwrvgnd_1
XTAP_767 VGND VPWR sky130_fd_sc_hd__tapvpwrvgnd_1
XTAP_778 VGND VPWR sky130_fd_sc_hd__tapvpwrvgnd_1
X_2234_ _1140_ VGND VGND VPWR VPWR _1141_ sky130_fd_sc_hd__clkbuf_4
XTAP_789 VGND VPWR sky130_fd_sc_hd__tapvpwrvgnd_1
X_2165_ _1109_ _1101_ _1103_ net243 VGND VGND VPWR VPWR _0201_ sky130_fd_sc_hd__a22o_1
XFILLER_0_8_533 VGND VGND VPWR VPWR sky130_fd_sc_hd__decap_8
XFILLER_0_61_94 VGND VGND VPWR VPWR sky130_fd_sc_hd__fill_2
X_2998_ fifo2.mem\[8\]\[6\] fifo2.mem\[9\]\[6\] fifo2.mem\[10\]\[6\] fifo2.mem\[11\]\[6\]
+ _1569_ _1540_ VGND VGND VPWR VPWR _1700_ sky130_fd_sc_hd__mux4_1
XFILLER_0_9_51 VGND VGND VPWR VPWR sky130_fd_sc_hd__decap_4
XFILLER_0_43_141 VPWR VGND VPWR VGND sky130_ef_sc_hd__decap_12
X_4737_ clknet_leaf_4_clock _0543_ VGND VGND VPWR VPWR fifo3.count\[3\] sky130_fd_sc_hd__dfxtp_1
X_4668_ clknet_leaf_60_clock _0474_ VGND VGND VPWR VPWR fifo3.mem\[9\]\[0\] sky130_fd_sc_hd__dfxtp_1
X_3619_ net2 net1 net9 VGND VGND VPWR VPWR _0657_ sky130_fd_sc_hd__nor3b_1
X_4599_ clknet_leaf_13_clock _0405_ VGND VGND VPWR VPWR fifo1.mem\[1\]\[1\] sky130_fd_sc_hd__dfxtp_1
XFILLER_0_3_293 VGND VGND VPWR VPWR sky130_fd_sc_hd__fill_2
XFILLER_0_66_277 VGND VGND VPWR VPWR sky130_fd_sc_hd__fill_1
XFILLER_0_81_225 VGND VGND VPWR VPWR sky130_fd_sc_hd__decap_6
XFILLER_0_54_439 VPWR VGND VPWR VGND sky130_ef_sc_hd__decap_12
XFILLER_0_15_21 VPWR VGND VPWR VGND sky130_ef_sc_hd__decap_12
X_3970_ _0915_ VGND VGND VPWR VPWR _0101_ sky130_fd_sc_hd__clkbuf_1
X_2921_ _0007_ VGND VGND VPWR VPWR _1625_ sky130_fd_sc_hd__clkbuf_4
X_2852_ _0005_ VGND VGND VPWR VPWR _1558_ sky130_fd_sc_hd__clkbuf_4
X_2783_ fifo2.count\[4\] fifo2.count\[3\] VGND VGND VPWR VPWR _1502_ sky130_fd_sc_hd__nor2_1
Xclkbuf_leaf_43_clock clknet_3_5__leaf_clock VGND VGND VPWR VPWR clknet_leaf_43_clock
+ sky130_fd_sc_hd__clkbuf_16
XFILLER_0_25_163 VGND VGND VPWR VPWR sky130_fd_sc_hd__decap_4
X_4522_ clknet_leaf_21_clock _0328_ VGND VGND VPWR VPWR fifo2.mem\[4\]\[5\] sky130_fd_sc_hd__dfxtp_1
Xhold226 fifo1.mem\[3\]\[2\] VGND VGND VPWR VPWR net274 sky130_fd_sc_hd__dlygate4sd3_1
X_4453_ clknet_leaf_18_clock _0259_ VGND VGND VPWR VPWR fifo1.count\[1\] sky130_fd_sc_hd__dfxtp_1
Xhold204 fifo1.mem\[11\]\[0\] VGND VGND VPWR VPWR net252 sky130_fd_sc_hd__dlygate4sd3_1
Xhold215 fifo1.mem\[8\]\[2\] VGND VGND VPWR VPWR net263 sky130_fd_sc_hd__dlygate4sd3_1
X_3404_ fifo3.mem\[8\]\[8\] fifo3.mem\[9\]\[8\] fifo3.mem\[10\]\[8\] fifo3.mem\[11\]\[8\]
+ _1849_ _1893_ VGND VGND VPWR VPWR _2010_ sky130_fd_sc_hd__mux4_1
Xhold259 fifo2.mem\[0\]\[2\] VGND VGND VPWR VPWR net307 sky130_fd_sc_hd__dlygate4sd3_1
Xhold248 fifo2.mem\[0\]\[6\] VGND VGND VPWR VPWR net296 sky130_fd_sc_hd__dlygate4sd3_1
Xhold237 fifo1.mem\[11\]\[5\] VGND VGND VPWR VPWR net285 sky130_fd_sc_hd__dlygate4sd3_1
Xclkbuf_leaf_58_clock clknet_3_1__leaf_clock VGND VGND VPWR VPWR clknet_leaf_58_clock
+ sky130_fd_sc_hd__clkbuf_16
X_4384_ clknet_leaf_7_clock _0198_ VGND VGND VPWR VPWR fifo1.mem\[5\]\[4\] sky130_fd_sc_hd__dfxtp_1
X_3335_ _1846_ fifo3.mem\[2\]\[6\] _1857_ VGND VGND VPWR VPWR _1961_ sky130_fd_sc_hd__o21a_1
XTAP_520 VGND VPWR sky130_fd_sc_hd__tapvpwrvgnd_1
XTAP_531 VGND VPWR sky130_fd_sc_hd__tapvpwrvgnd_1
XTAP_542 VGND VPWR sky130_fd_sc_hd__tapvpwrvgnd_1
X_3266_ fifo3.mem\[13\]\[4\] _1830_ VGND VGND VPWR VPWR _1894_ sky130_fd_sc_hd__and2b_1
XTAP_553 VGND VPWR sky130_fd_sc_hd__tapvpwrvgnd_1
XTAP_564 VGND VPWR sky130_fd_sc_hd__tapvpwrvgnd_1
XTAP_575 VGND VPWR sky130_fd_sc_hd__tapvpwrvgnd_1
XTAP_586 VGND VPWR sky130_fd_sc_hd__tapvpwrvgnd_1
XTAP_597 VGND VPWR sky130_fd_sc_hd__tapvpwrvgnd_1
X_2217_ _0766_ _1120_ _1125_ _1134_ VGND VGND VPWR VPWR _0228_ sky130_fd_sc_hd__a31o_1
X_3197_ _0010_ VGND VGND VPWR VPWR _1827_ sky130_fd_sc_hd__buf_6
XFILLER_0_22_3 VGND VGND VPWR VPWR sky130_fd_sc_hd__fill_1
X_2148_ _0748_ _0751_ _0753_ _1099_ VGND VGND VPWR VPWR _1100_ sky130_fd_sc_hd__and4_1
XFILLER_0_72_82 VGND VGND VPWR VPWR sky130_fd_sc_hd__fill_2
XFILLER_0_16_141 VGND VGND VPWR VPWR sky130_fd_sc_hd__decap_8
XFILLER_0_44_461 VPWR VGND VPWR VGND sky130_ef_sc_hd__decap_12
XFILLER_0_31_111 VGND VGND VPWR VPWR sky130_fd_sc_hd__fill_1
XFILLER_0_31_166 VGND VGND VPWR VPWR sky130_fd_sc_hd__fill_2
XFILLER_0_86_339 VPWR VGND VPWR VGND sky130_ef_sc_hd__decap_12
XFILLER_0_67_520 VGND VGND VPWR VPWR sky130_fd_sc_hd__fill_1
XFILLER_0_82_501 VPWR VGND VPWR VGND sky130_ef_sc_hd__decap_12
XFILLER_0_35_472 VGND VGND VPWR VPWR sky130_fd_sc_hd__decap_4
XFILLER_0_22_122 VGND VGND VPWR VPWR sky130_fd_sc_hd__decap_6
X_3120_ _0936_ _1771_ _1785_ VGND VGND VPWR VPWR _0480_ sky130_fd_sc_hd__a21o_1
XFILLER_0_89_111 VGND VGND VPWR VPWR sky130_fd_sc_hd__fill_1
X_3051_ _0858_ _0972_ _0716_ _1424_ VGND VGND VPWR VPWR _1750_ sky130_fd_sc_hd__and4_1
XFILLER_0_89_155 VPWR VGND VPWR VGND sky130_ef_sc_hd__decap_12
XFILLER_0_9_105 VGND VGND VPWR VPWR sky130_fd_sc_hd__decap_6
XFILLER_0_58_520 VGND VGND VPWR VPWR sky130_fd_sc_hd__decap_3
XFILLER_0_85_361 VPWR VGND VPWR VGND sky130_ef_sc_hd__decap_12
X_3953_ syn.count2\[4\] _0902_ VGND VGND VPWR VPWR _0906_ sky130_fd_sc_hd__nand2_1
XFILLER_0_42_41 VPWR VGND VPWR VGND sky130_ef_sc_hd__decap_12
X_2904_ _1605_ _1606_ _1608_ VGND VGND VPWR VPWR _1609_ sky130_fd_sc_hd__o21ai_2
X_3884_ fifo2.wr_pointer\[3\] VGND VGND VPWR VPWR _0860_ sky130_fd_sc_hd__buf_2
X_2835_ fifo2.mem\[4\]\[8\] fifo2.mem\[5\]\[8\] fifo2.mem\[6\]\[8\] fifo2.mem\[7\]\[8\]
+ _1539_ _1540_ VGND VGND VPWR VPWR _1541_ sky130_fd_sc_hd__mux4_1
XFILLER_0_13_111 VGND VGND VPWR VPWR sky130_fd_sc_hd__fill_1
X_2766_ _1105_ _1494_ _1495_ net180 VGND VGND VPWR VPWR _0416_ sky130_fd_sc_hd__a22o_1
X_2697_ _1467_ _1438_ _0722_ fifo2.mem\[2\]\[8\] _1451_ VGND VGND VPWR VPWR _1476_
+ sky130_fd_sc_hd__o311a_1
X_4505_ clknet_leaf_40_clock _0311_ VGND VGND VPWR VPWR fifo2.mem\[10\]\[6\] sky130_fd_sc_hd__dfxtp_1
XFILLER_0_6_41 VPWR VGND VPWR VGND sky130_ef_sc_hd__decap_12
X_4436_ clknet_leaf_12_clock _0242_ VGND VGND VPWR VPWR fifo1.mem\[3\]\[3\] sky130_fd_sc_hd__dfxtp_1
X_4367_ clknet_leaf_21_clock _0181_ VGND VGND VPWR VPWR fifo2.mem\[15\]\[5\] sky130_fd_sc_hd__dfxtp_1
XTAP_350 VGND VPWR sky130_fd_sc_hd__tapvpwrvgnd_1
X_3318_ _1942_ fifo3.mem\[9\]\[6\] _1943_ VGND VGND VPWR VPWR _1944_ sky130_fd_sc_hd__o21ai_1
XFILLER_0_6_85 VPWR VGND VPWR VGND sky130_ef_sc_hd__decap_12
X_4298_ clknet_leaf_62_clock _0112_ VGND VGND VPWR VPWR fifo3.mem\[5\]\[7\] sky130_fd_sc_hd__dfxtp_1
XTAP_361 VGND VPWR sky130_fd_sc_hd__tapvpwrvgnd_1
XTAP_372 VGND VPWR sky130_fd_sc_hd__tapvpwrvgnd_1
XTAP_383 VGND VPWR sky130_fd_sc_hd__tapvpwrvgnd_1
XTAP_394 VGND VPWR sky130_fd_sc_hd__tapvpwrvgnd_1
X_3249_ _1816_ _1870_ _1877_ VGND VGND VPWR VPWR _1878_ sky130_fd_sc_hd__nand3_2
XPHY_12 VGND VGND VPWR VPWR sky130_fd_sc_hd__decap_3
XFILLER_0_68_339 VGND VGND VPWR VPWR sky130_fd_sc_hd__decap_6
XPHY_34 VGND VGND VPWR VPWR sky130_fd_sc_hd__decap_3
XPHY_23 VGND VGND VPWR VPWR sky130_fd_sc_hd__decap_3
XPHY_45 VGND VGND VPWR VPWR sky130_fd_sc_hd__decap_3
XPHY_56 VGND VGND VPWR VPWR sky130_fd_sc_hd__decap_3
XPHY_67 VGND VGND VPWR VPWR sky130_fd_sc_hd__decap_3
XPHY_78 VGND VGND VPWR VPWR sky130_fd_sc_hd__decap_3
XPHY_89 VGND VGND VPWR VPWR sky130_fd_sc_hd__decap_3
XFILLER_0_91_331 VGND VGND VPWR VPWR sky130_fd_sc_hd__decap_4
XFILLER_0_32_475 VGND VGND VPWR VPWR sky130_fd_sc_hd__fill_1
XFILLER_0_86_169 VGND VGND VPWR VPWR sky130_fd_sc_hd__decap_3
XFILLER_0_74_309 VGND VGND VPWR VPWR sky130_fd_sc_hd__fill_1
XFILLER_0_42_228 VGND VGND VPWR VPWR sky130_fd_sc_hd__fill_1
X_2620_ _0858_ _0717_ _0619_ _0851_ VGND VGND VPWR VPWR _1443_ sky130_fd_sc_hd__and4_1
XFILLER_0_70_515 VGND VGND VPWR VPWR sky130_fd_sc_hd__fill_2
XFILLER_0_88_15 VPWR VGND VPWR VGND sky130_ef_sc_hd__decap_12
XFILLER_0_2_325 VPWR VGND VPWR VGND sky130_ef_sc_hd__decap_12
X_2551_ _0833_ _1420_ _0841_ _0844_ fifo3.mem\[3\]\[6\] VGND VGND VPWR VPWR _1422_
+ sky130_fd_sc_hd__o311a_1
XFILLER_0_50_261 VGND VGND VPWR VPWR sky130_fd_sc_hd__decap_6
X_2482_ _1363_ _1364_ _1198_ VGND VGND VPWR VPWR _1365_ sky130_fd_sc_hd__o21ai_1
X_4221_ clknet_leaf_12_clock _0035_ VGND VGND VPWR VPWR fifo1.mem\[0\]\[0\] sky130_fd_sc_hd__dfxtp_1
X_4152_ fsm1.full_state fifo1.lfd_state _0660_ _0681_ VGND VGND VPWR VPWR _1040_ sky130_fd_sc_hd__and4bb_4
X_3103_ _0789_ VGND VGND VPWR VPWR _1775_ sky130_fd_sc_hd__clkbuf_4
X_4083_ _0678_ fsm1.ld_state _0677_ _0987_ VGND VGND VPWR VPWR _0988_ sky130_fd_sc_hd__a31oi_4
X_3034_ _1726_ _1728_ VGND VGND VPWR VPWR _1735_ sky130_fd_sc_hd__and2_1
XFILLER_0_77_169 VPWR VGND VPWR VGND sky130_ef_sc_hd__decap_12
XFILLER_0_46_501 VPWR VGND VPWR VGND sky130_ef_sc_hd__decap_12
X_3936_ fifo2.soft_reset _0893_ _0882_ VGND VGND VPWR VPWR _0089_ sky130_fd_sc_hd__o21a_1
XFILLER_0_18_225 VPWR VGND VPWR VGND sky130_ef_sc_hd__decap_12
XFILLER_0_73_386 VGND VGND VPWR VPWR sky130_fd_sc_hd__fill_1
X_3867_ _0762_ _0825_ _0830_ _0847_ VGND VGND VPWR VPWR _0066_ sky130_fd_sc_hd__a31o_1
X_2818_ _1529_ _1530_ _1187_ VGND VGND VPWR VPWR _1531_ sky130_fd_sc_hd__mux2_1
XFILLER_0_5_141 VGND VGND VPWR VPWR sky130_fd_sc_hd__decap_6
X_3798_ _0785_ _0789_ fifo3.mem\[7\]\[6\] VGND VGND VPWR VPWR _0795_ sky130_fd_sc_hd__and3_1
X_2749_ _1490_ VGND VGND VPWR VPWR _1491_ sky130_fd_sc_hd__clkbuf_4
XFILLER_0_41_261 VPWR VGND VPWR VGND sky130_ef_sc_hd__decap_12
XFILLER_0_1_391 VGND VGND VPWR VPWR sky130_fd_sc_hd__fill_1
X_4419_ clknet_leaf_8_clock _0233_ VGND VGND VPWR VPWR fifo1.mem\[6\]\[3\] sky130_fd_sc_hd__dfxtp_1
XTAP_191 VGND VPWR sky130_fd_sc_hd__tapvpwrvgnd_1
XFILLER_0_56_309 VGND VGND VPWR VPWR sky130_fd_sc_hd__decap_8
XFILLER_0_24_239 VGND VGND VPWR VPWR sky130_fd_sc_hd__fill_2
XFILLER_0_32_261 VGND VGND VPWR VPWR sky130_fd_sc_hd__decap_4
XFILLER_0_58_18 VGND VGND VPWR VPWR sky130_fd_sc_hd__fill_2
XFILLER_0_58_29 VGND VGND VPWR VPWR sky130_fd_sc_hd__fill_2
XFILLER_0_20_489 VGND VGND VPWR VPWR sky130_fd_sc_hd__decap_4
XFILLER_0_90_27 VGND VGND VPWR VPWR sky130_fd_sc_hd__fill_1
XFILLER_0_87_434 VPWR VGND VPWR VGND sky130_ef_sc_hd__decap_12
XFILLER_0_28_501 VPWR VGND VPWR VGND sky130_ef_sc_hd__decap_12
X_4770_ clknet_leaf_62_clock _0576_ VGND VGND VPWR VPWR fifo3.mem\[10\]\[7\] sky130_fd_sc_hd__dfxtp_1
XFILLER_0_55_353 VGND VGND VPWR VPWR sky130_fd_sc_hd__decap_4
X_3721_ _0737_ VGND VGND VPWR VPWR _0738_ sky130_fd_sc_hd__clkbuf_8
X_3652_ _0680_ _0681_ _0648_ VGND VGND VPWR VPWR _0685_ sky130_fd_sc_hd__and3_1
X_2603_ _1435_ _1437_ net329 _0868_ _1426_ VGND VGND VPWR VPWR _0311_ sky130_fd_sc_hd__a32o_1
X_3583_ fifo2.rd_pointer\[2\] fifo2.wr_pointer\[2\] VGND VGND VPWR VPWR _0621_ sky130_fd_sc_hd__and2_1
XFILLER_0_11_412 VGND VGND VPWR VPWR sky130_fd_sc_hd__fill_1
X_2534_ fifo3.rd_pointer\[3\] fifo3.rd_pointer\[2\] VGND VGND VPWR VPWR _1412_ sky130_fd_sc_hd__and2_1
XFILLER_0_11_445 VGND VGND VPWR VPWR sky130_fd_sc_hd__decap_3
X_2465_ _1335_ _1341_ _1346_ _1348_ VGND VGND VPWR VPWR _1349_ sky130_fd_sc_hd__o22ai_2
X_4204_ _1072_ _1073_ _1074_ _1075_ VGND VGND VPWR VPWR _1076_ sky130_fd_sc_hd__a22o_1
X_2396_ _1265_ _1270_ _1275_ _1281_ VGND VGND VPWR VPWR _1282_ sky130_fd_sc_hd__a22oi_4
X_4135_ _1030_ _0983_ VGND VGND VPWR VPWR _1031_ sky130_fd_sc_hd__and2_1
X_4066_ _0735_ _0859_ _0972_ VGND VGND VPWR VPWR _0978_ sky130_fd_sc_hd__and3_1
X_3017_ _1620_ fifo2.count\[3\] _1508_ fifo2.count\[4\] VGND VGND VPWR VPWR _1719_
+ sky130_fd_sc_hd__o31a_1
XFILLER_0_78_489 VPWR VGND VPWR VGND sky130_ef_sc_hd__decap_12
X_3919_ syn.count1\[2\] syn.count1\[3\] _0881_ _0879_ VGND VGND VPWR VPWR _0882_ sky130_fd_sc_hd__a31o_1
XFILLER_0_46_397 VGND VGND VPWR VPWR sky130_fd_sc_hd__decap_6
XFILLER_0_88_209 VPWR VGND VPWR VGND sky130_ef_sc_hd__decap_12
XFILLER_0_84_437 VPWR VGND VPWR VGND sky130_ef_sc_hd__decap_12
XFILLER_0_37_320 VGND VGND VPWR VPWR sky130_fd_sc_hd__fill_2
XFILLER_0_56_139 VGND VGND VPWR VPWR sky130_fd_sc_hd__fill_1
XFILLER_0_64_172 VGND VGND VPWR VPWR sky130_fd_sc_hd__decap_6
XFILLER_0_64_194 VGND VGND VPWR VPWR sky130_fd_sc_hd__fill_2
XTAP_916 VGND VPWR sky130_fd_sc_hd__tapvpwrvgnd_1
XTAP_905 VGND VPWR sky130_fd_sc_hd__tapvpwrvgnd_1
XFILLER_0_85_38 VGND VGND VPWR VPWR sky130_fd_sc_hd__fill_1
XTAP_949 VGND VPWR sky130_fd_sc_hd__tapvpwrvgnd_1
XTAP_938 VGND VPWR sky130_fd_sc_hd__tapvpwrvgnd_1
XTAP_927 VGND VPWR sky130_fd_sc_hd__tapvpwrvgnd_1
X_2250_ fifo1.soft_reset _1143_ _1146_ _0694_ VGND VGND VPWR VPWR _1147_ sky130_fd_sc_hd__and4bb_1
X_2181_ _0768_ _1114_ _1115_ net177 VGND VGND VPWR VPWR _0211_ sky130_fd_sc_hd__a22o_1
XFILLER_0_34_53 VPWR VGND VPWR VGND sky130_ef_sc_hd__decap_12
XFILLER_0_75_437 VGND VGND VPWR VPWR sky130_fd_sc_hd__fill_2
XFILLER_0_90_418 VGND VGND VPWR VPWR sky130_fd_sc_hd__fill_2
X_4753_ clknet_leaf_3_clock _0559_ VGND VGND VPWR VPWR fifo3.mem\[0\]\[8\] sky130_fd_sc_hd__dfxtp_1
XFILLER_0_28_386 VGND VGND VPWR VPWR sky130_fd_sc_hd__decap_4
X_3704_ _0619_ VGND VGND VPWR VPWR _0725_ sky130_fd_sc_hd__clkbuf_4
X_4684_ clknet_leaf_61_clock _0490_ VGND VGND VPWR VPWR fifo3.mem\[4\]\[7\] sky130_fd_sc_hd__dfxtp_1
X_3635_ fsm1.rst_int_reg _0648_ _0655_ _0670_ VGND VGND VPWR VPWR _0014_ sky130_fd_sc_hd__a211o_1
XFILLER_0_31_529 VPWR VGND VPWR VGND sky130_ef_sc_hd__decap_12
XFILLER_0_3_497 VGND VGND VPWR VPWR sky130_fd_sc_hd__decap_6
X_3566_ fifo1.rd_pointer\[4\] fifo1.wr_pointer\[4\] VGND VGND VPWR VPWR _0605_ sky130_fd_sc_hd__xor2_4
XFILLER_0_59_61 VGND VGND VPWR VPWR sky130_fd_sc_hd__fill_1
X_2517_ _1397_ _1398_ _0757_ VGND VGND VPWR VPWR _0264_ sky130_fd_sc_hd__a21oi_1
X_3497_ _0746_ _0870_ VGND VGND VPWR VPWR _2082_ sky130_fd_sc_hd__nand2_1
X_2448_ _1320_ fifo1.mem\[13\]\[6\] _1331_ VGND VGND VPWR VPWR _1332_ sky130_fd_sc_hd__o21ai_1
XFILLER_0_52_3 VGND VGND VPWR VPWR sky130_fd_sc_hd__fill_1
X_2379_ _1264_ _1185_ _0003_ VGND VGND VPWR VPWR _1265_ sky130_fd_sc_hd__a21oi_2
X_4118_ _1015_ _1017_ _1005_ VGND VGND VPWR VPWR _0147_ sky130_fd_sc_hd__a21boi_1
X_4049_ _0957_ _0961_ _0962_ fifo2.mem\[1\]\[5\] _0967_ VGND VGND VPWR VPWR _0968_
+ sky130_fd_sc_hd__o311a_1
XFILLER_0_78_275 VPWR VGND VPWR VGND sky130_ef_sc_hd__decap_12
XFILLER_0_19_320 VGND VGND VPWR VPWR sky130_fd_sc_hd__fill_1
XFILLER_0_38_139 VGND VGND VPWR VPWR sky130_fd_sc_hd__fill_1
XFILLER_0_81_429 VGND VGND VPWR VPWR sky130_fd_sc_hd__decap_4
XFILLER_0_74_470 VGND VGND VPWR VPWR sky130_fd_sc_hd__decap_6
XFILLER_0_34_301 VGND VGND VPWR VPWR sky130_fd_sc_hd__decap_6
XFILLER_0_22_529 VGND VGND VPWR VPWR sky130_fd_sc_hd__decap_3
Xhold8 fifo3.mem\[14\]\[0\] VGND VGND VPWR VPWR net56 sky130_fd_sc_hd__dlygate4sd3_1
XFILLER_0_89_529 VPWR VGND VPWR VGND sky130_ef_sc_hd__decap_12
XFILLER_0_72_429 VGND VGND VPWR VPWR sky130_fd_sc_hd__fill_2
XFILLER_0_65_492 VGND VGND VPWR VPWR sky130_fd_sc_hd__decap_4
XFILLER_0_52_153 VPWR VGND VPWR VGND sky130_ef_sc_hd__decap_12
XFILLER_0_13_529 VPWR VGND VPWR VGND sky130_ef_sc_hd__decap_12
XFILLER_0_20_44 VGND VGND VPWR VPWR sky130_fd_sc_hd__decap_6
XFILLER_0_40_304 VGND VGND VPWR VPWR sky130_fd_sc_hd__decap_4
X_3420_ _2023_ _2025_ _0694_ _0799_ VGND VGND VPWR VPWR _2026_ sky130_fd_sc_hd__o211a_1
XFILLER_0_52_197 VGND VGND VPWR VPWR sky130_fd_sc_hd__fill_1
XFILLER_0_0_445 VGND VGND VPWR VPWR sky130_fd_sc_hd__decap_3
X_3351_ _1966_ _1968_ _1975_ _1814_ VGND VGND VPWR VPWR _1976_ sky130_fd_sc_hd__a22oi_4
X_2302_ fifo1.mem\[0\]\[8\] fifo1.mem\[1\]\[8\] fifo1.mem\[2\]\[8\] fifo1.mem\[3\]\[8\]
+ _1189_ _1183_ VGND VGND VPWR VPWR _1190_ sky130_fd_sc_hd__mux4_1
XFILLER_0_0_489 VPWR VGND VPWR VGND sky130_ef_sc_hd__decap_12
XTAP_702 VGND VPWR sky130_fd_sc_hd__tapvpwrvgnd_1
XTAP_713 VGND VPWR sky130_fd_sc_hd__tapvpwrvgnd_1
XTAP_724 VGND VPWR sky130_fd_sc_hd__tapvpwrvgnd_1
X_3282_ _1830_ fifo3.mem\[4\]\[4\] _1841_ VGND VGND VPWR VPWR _1910_ sky130_fd_sc_hd__o21ba_1
XTAP_735 VGND VPWR sky130_fd_sc_hd__tapvpwrvgnd_1
XTAP_746 VGND VPWR sky130_fd_sc_hd__tapvpwrvgnd_1
XTAP_757 VGND VPWR sky130_fd_sc_hd__tapvpwrvgnd_1
XTAP_768 VGND VPWR sky130_fd_sc_hd__tapvpwrvgnd_1
X_2233_ _0750_ _1119_ _1111_ _1123_ VGND VGND VPWR VPWR _1140_ sky130_fd_sc_hd__and4_1
XTAP_779 VGND VPWR sky130_fd_sc_hd__tapvpwrvgnd_1
X_2164_ _0765_ VGND VGND VPWR VPWR _1109_ sky130_fd_sc_hd__buf_4
XFILLER_0_0_21 VGND VGND VPWR VPWR sky130_fd_sc_hd__decap_6
XFILLER_0_75_267 VPWR VGND VPWR VGND sky130_ef_sc_hd__decap_12
XFILLER_0_0_98 VPWR VGND VPWR VGND sky130_ef_sc_hd__decap_12
X_2997_ _1657_ _1658_ _1697_ _1698_ VGND VGND VPWR VPWR _1699_ sky130_fd_sc_hd__and4_1
X_4736_ clknet_leaf_4_clock _0542_ VGND VGND VPWR VPWR fifo3.count\[2\] sky130_fd_sc_hd__dfxtp_1
XFILLER_0_43_153 VGND VGND VPWR VPWR sky130_fd_sc_hd__decap_8
XFILLER_0_16_389 VGND VGND VPWR VPWR sky130_fd_sc_hd__decap_4
XFILLER_0_31_315 VPWR VGND VPWR VGND sky130_ef_sc_hd__decap_12
X_4667_ clknet_leaf_2_clock _0473_ VGND VGND VPWR VPWR fifo3.mem\[2\]\[8\] sky130_fd_sc_hd__dfxtp_1
X_3618_ fsm1.detect_add VGND VGND VPWR VPWR _0656_ sky130_fd_sc_hd__buf_2
X_4598_ clknet_leaf_13_clock _0404_ VGND VGND VPWR VPWR fifo1.mem\[1\]\[0\] sky130_fd_sc_hd__dfxtp_1
X_3549_ _0733_ _2105_ _2103_ _2104_ net326 VGND VGND VPWR VPWR _0589_ sky130_fd_sc_hd__a32o_1
XFILLER_0_86_92 VGND VGND VPWR VPWR sky130_fd_sc_hd__fill_2
XFILLER_0_86_81 VGND VGND VPWR VPWR sky130_fd_sc_hd__decap_3
XFILLER_0_54_418 VGND VGND VPWR VPWR sky130_fd_sc_hd__fill_2
XFILLER_0_19_183 VGND VGND VPWR VPWR sky130_fd_sc_hd__decap_3
XFILLER_0_66_29 VPWR VGND VPWR VGND sky130_ef_sc_hd__decap_12
XFILLER_0_89_337 VPWR VGND VPWR VGND sky130_ef_sc_hd__decap_12
XFILLER_0_15_33 VGND VGND VPWR VPWR sky130_fd_sc_hd__decap_3
X_2920_ _1584_ _1586_ _1623_ VGND VGND VPWR VPWR _1624_ sky130_fd_sc_hd__a21oi_1
XFILLER_0_57_223 VGND VGND VPWR VPWR sky130_fd_sc_hd__fill_1
XFILLER_0_31_21 VGND VGND VPWR VPWR sky130_fd_sc_hd__fill_2
X_2851_ _1556_ VGND VGND VPWR VPWR _1557_ sky130_fd_sc_hd__buf_4
X_2782_ fifo2.count\[2\] fifo2.count\[1\] fifo2.count\[0\] VGND VGND VPWR VPWR _1501_
+ sky130_fd_sc_hd__nor3_1
XFILLER_0_53_462 VGND VGND VPWR VPWR sky130_fd_sc_hd__decap_4
X_4521_ clknet_leaf_21_clock _0327_ VGND VGND VPWR VPWR fifo2.mem\[4\]\[4\] sky130_fd_sc_hd__dfxtp_1
XFILLER_0_80_281 VGND VGND VPWR VPWR sky130_fd_sc_hd__decap_8
X_4452_ clknet_leaf_17_clock _0258_ VGND VGND VPWR VPWR fifo1.count\[0\] sky130_fd_sc_hd__dfxtp_2
Xhold205 fifo2.mem\[15\]\[6\] VGND VGND VPWR VPWR net253 sky130_fd_sc_hd__dlygate4sd3_1
Xhold216 fifo1.mem\[10\]\[5\] VGND VGND VPWR VPWR net264 sky130_fd_sc_hd__dlygate4sd3_1
Xhold238 fifo1.mem\[14\]\[5\] VGND VGND VPWR VPWR net286 sky130_fd_sc_hd__dlygate4sd3_1
X_3403_ _2008_ _1809_ _1816_ VGND VGND VPWR VPWR _2009_ sky130_fd_sc_hd__a21oi_1
XFILLER_0_40_156 VGND VGND VPWR VPWR sky130_fd_sc_hd__fill_2
XFILLER_0_40_178 VGND VGND VPWR VPWR sky130_fd_sc_hd__decap_8
Xhold227 fifo1.mem\[11\]\[2\] VGND VGND VPWR VPWR net275 sky130_fd_sc_hd__dlygate4sd3_1
Xhold249 fifo2.mem\[4\]\[8\] VGND VGND VPWR VPWR net297 sky130_fd_sc_hd__dlygate4sd3_1
XFILLER_0_0_264 VGND VGND VPWR VPWR sky130_fd_sc_hd__fill_1
X_4383_ clknet_leaf_7_clock _0197_ VGND VGND VPWR VPWR fifo1.mem\[5\]\[3\] sky130_fd_sc_hd__dfxtp_1
X_3334_ _1942_ fifo3.mem\[1\]\[6\] _1959_ VGND VGND VPWR VPWR _1960_ sky130_fd_sc_hd__o21ai_1
XTAP_510 VGND VPWR sky130_fd_sc_hd__tapvpwrvgnd_1
XTAP_521 VGND VPWR sky130_fd_sc_hd__tapvpwrvgnd_1
XTAP_532 VGND VPWR sky130_fd_sc_hd__tapvpwrvgnd_1
XTAP_543 VGND VPWR sky130_fd_sc_hd__tapvpwrvgnd_1
X_3265_ _1841_ VGND VGND VPWR VPWR _1893_ sky130_fd_sc_hd__buf_4
XTAP_554 VGND VPWR sky130_fd_sc_hd__tapvpwrvgnd_1
XTAP_565 VGND VPWR sky130_fd_sc_hd__tapvpwrvgnd_1
XTAP_576 VGND VPWR sky130_fd_sc_hd__tapvpwrvgnd_1
XTAP_587 VGND VPWR sky130_fd_sc_hd__tapvpwrvgnd_1
XTAP_598 VGND VPWR sky130_fd_sc_hd__tapvpwrvgnd_1
X_2216_ _1126_ _1119_ fifo1.mem\[7\]\[7\] VGND VGND VPWR VPWR _1134_ sky130_fd_sc_hd__and3_1
X_3196_ _1821_ _1823_ _1816_ _1826_ _0875_ VGND VGND VPWR VPWR _0515_ sky130_fd_sc_hd__o221a_1
X_2147_ _0613_ _0749_ VGND VGND VPWR VPWR _1099_ sky130_fd_sc_hd__and2b_1
XFILLER_0_48_212 VGND VGND VPWR VPWR sky130_fd_sc_hd__decap_3
XFILLER_0_48_267 VGND VGND VPWR VPWR sky130_fd_sc_hd__fill_2
XFILLER_0_36_429 VGND VGND VPWR VPWR sky130_fd_sc_hd__decap_3
XFILLER_0_16_131 VGND VGND VPWR VPWR sky130_fd_sc_hd__fill_2
XFILLER_0_71_270 VGND VGND VPWR VPWR sky130_fd_sc_hd__decap_8
X_4719_ clknet_leaf_54_clock _0525_ VGND VGND VPWR VPWR fifo3.wr_pointer\[3\] sky130_fd_sc_hd__dfxtp_2
XFILLER_0_44_473 VGND VGND VPWR VPWR sky130_fd_sc_hd__decap_3
XFILLER_0_71_281 VGND VGND VPWR VPWR sky130_fd_sc_hd__decap_3
XFILLER_0_86_307 VGND VGND VPWR VPWR sky130_fd_sc_hd__fill_1
XFILLER_0_82_513 VPWR VGND VPWR VGND sky130_ef_sc_hd__decap_12
XFILLER_0_62_270 VGND VGND VPWR VPWR sky130_fd_sc_hd__decap_3
XFILLER_0_50_421 VGND VGND VPWR VPWR sky130_fd_sc_hd__fill_2
X_3050_ _1748_ VGND VGND VPWR VPWR _1749_ sky130_fd_sc_hd__buf_2
XFILLER_0_89_167 VGND VGND VPWR VPWR sky130_fd_sc_hd__fill_1
XFILLER_0_73_502 VGND VGND VPWR VPWR sky130_fd_sc_hd__fill_2
X_3952_ syn.count2\[0\] syn.count2\[1\] syn.count2\[3\] syn.count2\[2\] syn.count2\[4\]
+ VGND VGND VPWR VPWR _0905_ sky130_fd_sc_hd__a41o_1
XFILLER_0_42_53 VPWR VGND VPWR VGND sky130_ef_sc_hd__decap_12
XFILLER_0_85_373 VGND VGND VPWR VPWR sky130_fd_sc_hd__decap_3
X_3883_ _0858_ VGND VGND VPWR VPWR _0859_ sky130_fd_sc_hd__buf_2
X_2903_ fifo2.mem\[15\]\[3\] _1572_ _1607_ VGND VGND VPWR VPWR _1608_ sky130_fd_sc_hd__o21ai_1
X_2834_ _0005_ VGND VGND VPWR VPWR _1540_ sky130_fd_sc_hd__buf_4
XFILLER_0_5_389 VGND VGND VPWR VPWR sky130_fd_sc_hd__decap_3
X_4504_ clknet_leaf_40_clock _0310_ VGND VGND VPWR VPWR fifo2.mem\[10\]\[5\] sky130_fd_sc_hd__dfxtp_1
XFILLER_0_53_270 VGND VGND VPWR VPWR sky130_fd_sc_hd__decap_8
XFILLER_0_53_281 VPWR VGND VPWR VGND sky130_ef_sc_hd__decap_12
X_2765_ _1104_ _1494_ _1495_ net136 VGND VGND VPWR VPWR _0415_ sky130_fd_sc_hd__a22o_1
X_2696_ _0766_ _0724_ _1436_ _1475_ VGND VGND VPWR VPWR _0366_ sky130_fd_sc_hd__a31o_1
XFILLER_0_13_167 VGND VGND VPWR VPWR sky130_fd_sc_hd__fill_1
X_4435_ clknet_leaf_12_clock _0241_ VGND VGND VPWR VPWR fifo1.mem\[3\]\[2\] sky130_fd_sc_hd__dfxtp_1
XFILLER_0_6_53 VPWR VGND VPWR VGND sky130_ef_sc_hd__decap_12
X_4366_ clknet_leaf_21_clock _0180_ VGND VGND VPWR VPWR fifo2.mem\[15\]\[4\] sky130_fd_sc_hd__dfxtp_1
XTAP_351 VGND VPWR sky130_fd_sc_hd__tapvpwrvgnd_1
X_3317_ _1805_ fifo3.mem\[8\]\[6\] _1893_ VGND VGND VPWR VPWR _1943_ sky130_fd_sc_hd__o21ba_1
XTAP_340 VGND VPWR sky130_fd_sc_hd__tapvpwrvgnd_1
XFILLER_0_6_97 VPWR VGND VPWR VGND sky130_ef_sc_hd__decap_12
XTAP_362 VGND VPWR sky130_fd_sc_hd__tapvpwrvgnd_1
XTAP_373 VGND VPWR sky130_fd_sc_hd__tapvpwrvgnd_1
XTAP_384 VGND VPWR sky130_fd_sc_hd__tapvpwrvgnd_1
X_4297_ clknet_leaf_62_clock _0111_ VGND VGND VPWR VPWR fifo3.mem\[5\]\[6\] sky130_fd_sc_hd__dfxtp_1
XTAP_395 VGND VPWR sky130_fd_sc_hd__tapvpwrvgnd_1
X_3248_ _1873_ _1876_ _0010_ VGND VGND VPWR VPWR _1877_ sky130_fd_sc_hd__o21bai_1
X_3179_ _0010_ VGND VGND VPWR VPWR _1811_ sky130_fd_sc_hd__inv_2
XPHY_13 VGND VGND VPWR VPWR sky130_fd_sc_hd__decap_3
XPHY_35 VGND VGND VPWR VPWR sky130_fd_sc_hd__decap_3
XPHY_24 VGND VGND VPWR VPWR sky130_fd_sc_hd__decap_3
XPHY_46 VGND VGND VPWR VPWR sky130_fd_sc_hd__decap_3
XPHY_57 VGND VGND VPWR VPWR sky130_fd_sc_hd__decap_3
XPHY_68 VGND VGND VPWR VPWR sky130_fd_sc_hd__decap_3
XPHY_79 VGND VGND VPWR VPWR sky130_fd_sc_hd__decap_3
XFILLER_0_91_321 VGND VGND VPWR VPWR sky130_fd_sc_hd__decap_4
XFILLER_0_91_365 VGND VGND VPWR VPWR sky130_fd_sc_hd__decap_8
XFILLER_0_8_194 VGND VGND VPWR VPWR sky130_fd_sc_hd__fill_2
XFILLER_0_4_3 VPWR VGND VPWR VGND sky130_ef_sc_hd__decap_12
Xclkbuf_leaf_42_clock clknet_3_5__leaf_clock VGND VGND VPWR VPWR clknet_leaf_42_clock
+ sky130_fd_sc_hd__clkbuf_16
XFILLER_0_82_321 VPWR VGND VPWR VGND sky130_ef_sc_hd__decap_12
Xclkbuf_leaf_57_clock clknet_3_1__leaf_clock VGND VGND VPWR VPWR clknet_leaf_57_clock
+ sky130_fd_sc_hd__clkbuf_16
XFILLER_0_6_109 VGND VGND VPWR VPWR sky130_fd_sc_hd__decap_6
XFILLER_0_82_365 VPWR VGND VPWR VGND sky130_ef_sc_hd__decap_12
XFILLER_0_88_27 VGND VGND VPWR VPWR sky130_fd_sc_hd__fill_1
XFILLER_0_23_421 VGND VGND VPWR VPWR sky130_fd_sc_hd__fill_2
XFILLER_0_35_281 VGND VGND VPWR VPWR sky130_fd_sc_hd__decap_3
XFILLER_0_2_337 VPWR VGND VPWR VGND sky130_ef_sc_hd__decap_12
XFILLER_0_23_476 VPWR VGND VPWR VGND sky130_ef_sc_hd__decap_12
X_2550_ _0740_ _1416_ _0837_ _1418_ net184 VGND VGND VPWR VPWR _0274_ sky130_fd_sc_hd__a32o_1
X_2481_ _1305_ _1308_ _1175_ VGND VGND VPWR VPWR _1364_ sky130_fd_sc_hd__o21a_1
X_4220_ clknet_leaf_28_clock _0034_ VGND VGND VPWR VPWR fifo2.mem\[3\]\[8\] sky130_fd_sc_hd__dfxtp_1
XFILLER_0_10_137 VGND VGND VPWR VPWR sky130_fd_sc_hd__decap_3
X_4151_ _0680_ _1039_ fsm1.parity_done _0674_ VGND VGND VPWR VPWR _0158_ sky130_fd_sc_hd__a2bb2o_1
X_3102_ _1773_ VGND VGND VPWR VPWR _1774_ sky130_fd_sc_hd__buf_2
X_4082_ fsm1.ld_state _0660_ VGND VGND VPWR VPWR _0987_ sky130_fd_sc_hd__and2b_1
X_3033_ _1724_ _1699_ _1712_ _1733_ VGND VGND VPWR VPWR _1734_ sky130_fd_sc_hd__nand4_1
XFILLER_0_58_340 VPWR VGND VPWR VGND sky130_ef_sc_hd__decap_12
X_3935_ _0891_ _0892_ _0893_ VGND VGND VPWR VPWR _0088_ sky130_fd_sc_hd__o21a_1
XFILLER_0_46_513 VPWR VGND VPWR VGND sky130_ef_sc_hd__decap_12
XFILLER_0_18_237 VGND VGND VPWR VPWR sky130_fd_sc_hd__decap_8
XFILLER_0_73_376 VGND VGND VPWR VPWR sky130_fd_sc_hd__fill_2
XFILLER_0_73_365 VGND VGND VPWR VPWR sky130_fd_sc_hd__decap_4
X_3866_ _0832_ _0840_ _0841_ _0844_ fifo3.mem\[1\]\[4\] VGND VGND VPWR VPWR _0847_
+ sky130_fd_sc_hd__o311a_1
XFILLER_0_61_505 VGND VGND VPWR VPWR sky130_fd_sc_hd__decap_6
XFILLER_0_61_516 VGND VGND VPWR VPWR sky130_fd_sc_hd__fill_1
XFILLER_0_82_3 VGND VGND VPWR VPWR sky130_fd_sc_hd__decap_8
XFILLER_0_26_281 VGND VGND VPWR VPWR sky130_fd_sc_hd__fill_2
X_3797_ _0763_ _0778_ _0790_ _0794_ VGND VGND VPWR VPWR _0049_ sky130_fd_sc_hd__a31o_1
X_2817_ fifo1.mem\[8\]\[1\] fifo1.mem\[9\]\[1\] fifo1.mem\[10\]\[1\] fifo1.mem\[11\]\[1\]
+ _1317_ _1339_ VGND VGND VPWR VPWR _1530_ sky130_fd_sc_hd__mux4_2
X_2748_ fifo1.wr_pointer\[0\] _0750_ _0751_ _0753_ VGND VGND VPWR VPWR _1490_ sky130_fd_sc_hd__and4_1
XFILLER_0_41_273 VGND VGND VPWR VPWR sky130_fd_sc_hd__decap_6
X_2679_ _0768_ _1465_ _1466_ net133 VGND VGND VPWR VPWR _0358_ sky130_fd_sc_hd__a22o_1
XFILLER_0_41_295 VGND VGND VPWR VPWR sky130_fd_sc_hd__decap_4
X_4418_ clknet_leaf_5_clock _0232_ VGND VGND VPWR VPWR fifo1.mem\[6\]\[2\] sky130_fd_sc_hd__dfxtp_1
X_4349_ clknet_leaf_44_clock _0163_ VGND VGND VPWR VPWR regis.internal_parity\[4\]
+ sky130_fd_sc_hd__dfxtp_1
XTAP_192 VGND VPWR sky130_fd_sc_hd__tapvpwrvgnd_1
XFILLER_0_37_502 VGND VGND VPWR VPWR sky130_fd_sc_hd__fill_2
XFILLER_0_91_195 VGND VGND VPWR VPWR sky130_fd_sc_hd__fill_1
XFILLER_0_17_281 VGND VGND VPWR VPWR sky130_fd_sc_hd__decap_6
XFILLER_0_32_240 VGND VGND VPWR VPWR sky130_fd_sc_hd__fill_1
XFILLER_0_87_446 VGND VGND VPWR VPWR sky130_fd_sc_hd__fill_2
XFILLER_0_28_513 VPWR VGND VPWR VGND sky130_ef_sc_hd__decap_12
X_3720_ fifo1.data_in\[4\] VGND VGND VPWR VPWR _0737_ sky130_fd_sc_hd__buf_4
X_3651_ fifo1.lfd_state VGND VGND VPWR VPWR _0684_ sky130_fd_sc_hd__buf_2
XFILLER_0_2_112 VGND VGND VPWR VPWR sky130_fd_sc_hd__decap_3
X_2602_ _1435_ _1437_ fifo2.mem\[10\]\[5\] _0866_ _1426_ VGND VGND VPWR VPWR _0310_
+ sky130_fd_sc_hd__a32o_1
X_3582_ fifo2.rd_pointer\[2\] _0619_ VGND VGND VPWR VPWR _0620_ sky130_fd_sc_hd__nor2_1
X_2533_ _1411_ VGND VGND VPWR VPWR _0267_ sky130_fd_sc_hd__clkbuf_1
X_2464_ _1347_ _1200_ _0003_ VGND VGND VPWR VPWR _1348_ sky130_fd_sc_hd__a21o_1
X_4203_ regis.packet_parity\[7\] regis.internal_parity\[7\] VGND VGND VPWR VPWR _1075_
+ sky130_fd_sc_hd__nand2_1
XFILLER_0_48_63 VGND VGND VPWR VPWR sky130_fd_sc_hd__decap_4
X_2395_ _1280_ _1185_ _1198_ VGND VGND VPWR VPWR _1281_ sky130_fd_sc_hd__a21oi_1
X_4134_ regis.header_byte\[1\] _1027_ _0664_ fsm1.detect_add VGND VGND VPWR VPWR _1030_
+ sky130_fd_sc_hd__a22o_1
XFILLER_0_3_43 VPWR VGND VPWR VGND sky130_ef_sc_hd__decap_12
X_4065_ _0976_ _0867_ net307 net47 _0977_ VGND VGND VPWR VPWR _0134_ sky130_fd_sc_hd__a32o_1
X_3016_ net41 _1501_ _1502_ net11 VGND VGND VPWR VPWR _1718_ sky130_fd_sc_hd__and4_1
XFILLER_0_65_118 VPWR VGND VPWR VGND sky130_ef_sc_hd__decap_12
X_3918_ syn.count1\[1\] syn.count1\[5\] syn.count1\[4\] syn.count1\[0\] VGND VGND
+ VPWR VPWR _0881_ sky130_fd_sc_hd__and4bb_1
XFILLER_0_34_505 VPWR VGND VPWR VGND sky130_ef_sc_hd__decap_12
X_3849_ _0773_ _0827_ _0775_ _0634_ VGND VGND VPWR VPWR _0834_ sky130_fd_sc_hd__o211ai_4
XFILLER_0_61_368 VGND VGND VPWR VPWR sky130_fd_sc_hd__fill_1
XFILLER_0_89_81 VPWR VGND VPWR VGND sky130_ef_sc_hd__decap_12
XFILLER_0_84_405 VGND VGND VPWR VPWR sky130_fd_sc_hd__decap_6
XFILLER_0_69_457 VGND VGND VPWR VPWR sky130_fd_sc_hd__fill_2
XFILLER_0_56_118 VGND VGND VPWR VPWR sky130_fd_sc_hd__fill_2
XFILLER_0_84_449 VPWR VGND VPWR VGND sky130_ef_sc_hd__decap_12
XFILLER_0_25_505 VPWR VGND VPWR VGND sky130_ef_sc_hd__decap_12
XFILLER_0_52_313 VGND VGND VPWR VPWR sky130_fd_sc_hd__decap_4
XTAP_917 VGND VPWR sky130_fd_sc_hd__tapvpwrvgnd_1
XTAP_906 VGND VPWR sky130_fd_sc_hd__tapvpwrvgnd_1
XTAP_939 VGND VPWR sky130_fd_sc_hd__tapvpwrvgnd_1
XTAP_928 VGND VPWR sky130_fd_sc_hd__tapvpwrvgnd_1
X_2180_ _1109_ _1114_ _1115_ net194 VGND VGND VPWR VPWR _0210_ sky130_fd_sc_hd__a22o_1
XFILLER_0_18_77 VGND VGND VPWR VPWR sky130_fd_sc_hd__fill_1
XFILLER_0_34_21 VGND VGND VPWR VPWR sky130_fd_sc_hd__decap_6
XFILLER_0_34_65 VPWR VGND VPWR VGND sky130_ef_sc_hd__decap_12
XFILLER_0_47_129 VGND VGND VPWR VPWR sky130_fd_sc_hd__decap_4
XFILLER_0_16_505 VPWR VGND VPWR VGND sky130_ef_sc_hd__decap_12
XFILLER_0_28_343 VGND VGND VPWR VPWR sky130_fd_sc_hd__decap_4
X_4752_ clknet_leaf_4_clock _0558_ VGND VGND VPWR VPWR fifo3.mem\[0\]\[7\] sky130_fd_sc_hd__dfxtp_1
X_4683_ clknet_leaf_62_clock _0489_ VGND VGND VPWR VPWR fifo3.mem\[4\]\[6\] sky130_fd_sc_hd__dfxtp_1
XFILLER_0_43_313 VGND VGND VPWR VPWR sky130_fd_sc_hd__decap_3
XFILLER_0_43_324 VPWR VGND VPWR VGND sky130_ef_sc_hd__decap_12
X_3703_ _0723_ VGND VGND VPWR VPWR _0724_ sky130_fd_sc_hd__clkbuf_4
X_3634_ _0656_ _0665_ _0669_ _0654_ VGND VGND VPWR VPWR _0670_ sky130_fd_sc_hd__and4_1
X_3565_ _0767_ _1753_ _0920_ _2106_ net71 VGND VGND VPWR VPWR _0604_ sky130_fd_sc_hd__a32o_1
X_2516_ _1325_ _1370_ _1386_ _1195_ VGND VGND VPWR VPWR _1398_ sky130_fd_sc_hd__nand4b_1
X_3496_ _0712_ _0746_ _0871_ _2081_ net80 VGND VGND VPWR VPWR _0560_ sky130_fd_sc_hd__a32o_1
X_2447_ _1295_ fifo1.mem\[12\]\[6\] _1178_ VGND VGND VPWR VPWR _1331_ sky130_fd_sc_hd__o21ba_1
XFILLER_0_45_3 VPWR VGND VPWR VGND sky130_ef_sc_hd__decap_12
X_2378_ _1260_ _1261_ _1262_ _1263_ VGND VGND VPWR VPWR _1264_ sky130_fd_sc_hd__o22ai_2
X_4117_ regis.header_byte\[5\] _0684_ _1016_ _0988_ VGND VGND VPWR VPWR _1017_ sky130_fd_sc_hd__o2bb2a_1
X_4048_ _0719_ VGND VGND VPWR VPWR _0967_ sky130_fd_sc_hd__clkbuf_4
XFILLER_0_78_287 VPWR VGND VPWR VGND sky130_ef_sc_hd__decap_12
XFILLER_0_66_405 VPWR VGND VPWR VGND sky130_ef_sc_hd__decap_12
XFILLER_0_46_195 VGND VGND VPWR VPWR sky130_fd_sc_hd__fill_1
XFILLER_0_61_154 VGND VGND VPWR VPWR sky130_fd_sc_hd__fill_1
XFILLER_0_61_176 VGND VGND VPWR VPWR sky130_fd_sc_hd__fill_2
Xhold9 fifo1.mem\[15\]\[2\] VGND VGND VPWR VPWR net57 sky130_fd_sc_hd__dlygate4sd3_1
XFILLER_0_69_221 VGND VGND VPWR VPWR sky130_fd_sc_hd__decap_3
XFILLER_0_57_449 VPWR VGND VPWR VGND sky130_ef_sc_hd__decap_12
XFILLER_0_4_229 VGND VGND VPWR VPWR sky130_fd_sc_hd__decap_6
XFILLER_0_25_335 VGND VGND VPWR VPWR sky130_fd_sc_hd__fill_1
XFILLER_0_0_413 VGND VGND VPWR VPWR sky130_fd_sc_hd__decap_6
XFILLER_0_33_390 VGND VGND VPWR VPWR sky130_fd_sc_hd__fill_2
X_3350_ _1969_ _1809_ _1974_ VGND VGND VPWR VPWR _1975_ sky130_fd_sc_hd__a21oi_2
X_2301_ _1188_ VGND VGND VPWR VPWR _1189_ sky130_fd_sc_hd__clkbuf_4
XFILLER_0_0_457 VGND VGND VPWR VPWR sky130_fd_sc_hd__fill_1
XTAP_703 VGND VPWR sky130_fd_sc_hd__tapvpwrvgnd_1
XTAP_714 VGND VPWR sky130_fd_sc_hd__tapvpwrvgnd_1
XTAP_725 VGND VPWR sky130_fd_sc_hd__tapvpwrvgnd_1
X_3281_ _1905_ _1906_ _1908_ VGND VGND VPWR VPWR _1909_ sky130_fd_sc_hd__o21a_1
XTAP_736 VGND VPWR sky130_fd_sc_hd__tapvpwrvgnd_1
XTAP_747 VGND VPWR sky130_fd_sc_hd__tapvpwrvgnd_1
XTAP_758 VGND VPWR sky130_fd_sc_hd__tapvpwrvgnd_1
X_2232_ net215 _1137_ _1139_ _0939_ VGND VGND VPWR VPWR _0238_ sky130_fd_sc_hd__a22o_1
XTAP_769 VGND VPWR sky130_fd_sc_hd__tapvpwrvgnd_1
X_2163_ _1108_ _1101_ _1103_ net55 VGND VGND VPWR VPWR _0200_ sky130_fd_sc_hd__a22o_1
XFILLER_0_0_44 VPWR VGND VPWR VGND sky130_ef_sc_hd__decap_12
XFILLER_0_75_279 VGND VGND VPWR VPWR sky130_fd_sc_hd__fill_1
XFILLER_0_28_173 VPWR VGND VPWR VGND sky130_ef_sc_hd__decap_12
X_4735_ clknet_leaf_4_clock _0541_ VGND VGND VPWR VPWR fifo3.count\[1\] sky130_fd_sc_hd__dfxtp_1
XFILLER_0_56_482 VGND VGND VPWR VPWR sky130_fd_sc_hd__decap_6
X_2996_ _1538_ _1672_ _1678_ VGND VGND VPWR VPWR _1698_ sky130_fd_sc_hd__nand3_1
XFILLER_0_31_327 VGND VGND VPWR VPWR sky130_fd_sc_hd__decap_8
X_4666_ clknet_leaf_2_clock _0472_ VGND VGND VPWR VPWR fifo3.mem\[2\]\[7\] sky130_fd_sc_hd__dfxtp_1
X_3617_ fsm1.parity_done fsm1.laf_state _0654_ VGND VGND VPWR VPWR _0655_ sky130_fd_sc_hd__a21bo_1
X_4597_ clknet_leaf_8_clock _0403_ VGND VGND VPWR VPWR fifo1.mem\[10\]\[8\] sky130_fd_sc_hd__dfxtp_1
X_3548_ _0731_ _2105_ _2103_ _2104_ net146 VGND VGND VPWR VPWR _0588_ sky130_fd_sc_hd__a32o_1
X_3479_ _2072_ _0783_ net316 _2073_ VGND VGND VPWR VPWR _0551_ sky130_fd_sc_hd__a31o_1
XFILLER_0_39_449 VGND VGND VPWR VPWR sky130_fd_sc_hd__decap_4
XFILLER_0_62_474 VGND VGND VPWR VPWR sky130_fd_sc_hd__fill_2
XFILLER_0_22_338 VGND VGND VPWR VPWR sky130_fd_sc_hd__decap_6
XFILLER_0_89_305 VPWR VGND VPWR VGND sky130_ef_sc_hd__decap_12
XFILLER_0_89_349 VPWR VGND VPWR VGND sky130_ef_sc_hd__decap_12
X_2850_ _0004_ VGND VGND VPWR VPWR _1556_ sky130_fd_sc_hd__clkbuf_4
XFILLER_0_5_505 VPWR VGND VPWR VGND sky130_ef_sc_hd__decap_12
XFILLER_0_38_471 VGND VGND VPWR VPWR sky130_fd_sc_hd__decap_4
XFILLER_0_25_121 VGND VGND VPWR VPWR sky130_fd_sc_hd__fill_1
XFILLER_0_31_55 VGND VGND VPWR VPWR sky130_fd_sc_hd__fill_1
X_2781_ _1500_ VGND VGND VPWR VPWR _0426_ sky130_fd_sc_hd__clkbuf_1
X_4520_ clknet_leaf_22_clock _0326_ VGND VGND VPWR VPWR fifo2.mem\[4\]\[3\] sky130_fd_sc_hd__dfxtp_1
Xhold206 fifo1.mem\[0\]\[5\] VGND VGND VPWR VPWR net254 sky130_fd_sc_hd__dlygate4sd3_1
Xhold217 fifo3.mem\[0\]\[2\] VGND VGND VPWR VPWR net265 sky130_fd_sc_hd__dlygate4sd3_1
XFILLER_0_40_113 VGND VGND VPWR VPWR sky130_fd_sc_hd__decap_4
X_4451_ clknet_leaf_5_clock _0257_ VGND VGND VPWR VPWR fifo1.rd_pointer\[4\] sky130_fd_sc_hd__dfxtp_2
XFILLER_0_53_496 VGND VGND VPWR VPWR sky130_fd_sc_hd__decap_8
Xhold239 fifo1.mem\[3\]\[8\] VGND VGND VPWR VPWR net287 sky130_fd_sc_hd__dlygate4sd3_1
Xhold228 fifo2.mem\[6\]\[1\] VGND VGND VPWR VPWR net276 sky130_fd_sc_hd__dlygate4sd3_1
X_3402_ fifo3.mem\[12\]\[8\] fifo3.mem\[13\]\[8\] fifo3.mem\[14\]\[8\] fifo3.mem\[15\]\[8\]
+ _1828_ _1893_ VGND VGND VPWR VPWR _2008_ sky130_fd_sc_hd__mux4_1
XFILLER_0_21_360 VGND VGND VPWR VPWR sky130_fd_sc_hd__decap_4
XTAP_500 VGND VPWR sky130_fd_sc_hd__tapvpwrvgnd_1
X_4382_ clknet_leaf_19_clock _0196_ VGND VGND VPWR VPWR fifo1.mem\[5\]\[2\] sky130_fd_sc_hd__dfxtp_1
X_3333_ _1828_ fifo3.mem\[0\]\[6\] _1857_ VGND VGND VPWR VPWR _1959_ sky130_fd_sc_hd__o21ba_1
XTAP_511 VGND VPWR sky130_fd_sc_hd__tapvpwrvgnd_1
XTAP_522 VGND VPWR sky130_fd_sc_hd__tapvpwrvgnd_1
XTAP_533 VGND VPWR sky130_fd_sc_hd__tapvpwrvgnd_1
X_3264_ _1892_ VGND VGND VPWR VPWR _0517_ sky130_fd_sc_hd__buf_1
XTAP_544 VGND VPWR sky130_fd_sc_hd__tapvpwrvgnd_1
XTAP_555 VGND VPWR sky130_fd_sc_hd__tapvpwrvgnd_1
XTAP_566 VGND VPWR sky130_fd_sc_hd__tapvpwrvgnd_1
XTAP_577 VGND VPWR sky130_fd_sc_hd__tapvpwrvgnd_1
XTAP_588 VGND VPWR sky130_fd_sc_hd__tapvpwrvgnd_1
XTAP_599 VGND VPWR sky130_fd_sc_hd__tapvpwrvgnd_1
X_2215_ _0764_ _1121_ _1125_ _1133_ VGND VGND VPWR VPWR _0227_ sky130_fd_sc_hd__a31o_1
X_3195_ _1824_ _1825_ _1812_ VGND VGND VPWR VPWR _1826_ sky130_fd_sc_hd__mux2_1
X_2146_ _0768_ _1096_ _1097_ net204 VGND VGND VPWR VPWR _0193_ sky130_fd_sc_hd__a22o_1
XFILLER_0_76_533 VGND VGND VPWR VPWR sky130_fd_sc_hd__decap_8
XFILLER_0_91_503 VGND VGND VPWR VPWR sky130_fd_sc_hd__fill_1
XFILLER_0_36_419 VGND VGND VPWR VPWR sky130_fd_sc_hd__fill_1
XFILLER_0_8_332 VGND VGND VPWR VPWR sky130_fd_sc_hd__fill_2
XFILLER_0_8_387 VGND VGND VPWR VPWR sky130_fd_sc_hd__decap_3
X_2979_ fifo2.mem\[15\]\[5\] _1582_ _1681_ VGND VGND VPWR VPWR _1682_ sky130_fd_sc_hd__o21ai_1
XFILLER_0_63_249 VGND VGND VPWR VPWR sky130_fd_sc_hd__fill_1
XFILLER_0_16_165 VGND VGND VPWR VPWR sky130_fd_sc_hd__decap_4
X_4718_ clknet_leaf_55_clock _0524_ VGND VGND VPWR VPWR fifo3.wr_pointer\[2\] sky130_fd_sc_hd__dfxtp_1
XFILLER_0_31_102 VGND VGND VPWR VPWR sky130_fd_sc_hd__decap_3
XFILLER_0_31_113 VGND VGND VPWR VPWR sky130_fd_sc_hd__fill_2
X_4649_ clknet_leaf_24_clock _0455_ VGND VGND VPWR VPWR fifo2.mem\[6\]\[8\] sky130_fd_sc_hd__dfxtp_1
XFILLER_0_31_146 VGND VGND VPWR VPWR sky130_fd_sc_hd__decap_4
XFILLER_0_67_500 VGND VGND VPWR VPWR sky130_fd_sc_hd__decap_4
XFILLER_0_82_525 VGND VGND VPWR VPWR sky130_fd_sc_hd__decap_6
XFILLER_0_39_279 VGND VGND VPWR VPWR sky130_fd_sc_hd__fill_1
XFILLER_0_22_113 VGND VGND VPWR VPWR sky130_fd_sc_hd__fill_2
XFILLER_0_35_485 VGND VGND VPWR VPWR sky130_fd_sc_hd__fill_1
XFILLER_0_22_135 VGND VGND VPWR VPWR sky130_fd_sc_hd__decap_4
XFILLER_0_77_29 VGND VGND VPWR VPWR sky130_fd_sc_hd__decap_3
XFILLER_0_89_113 VPWR VGND VPWR VGND sky130_ef_sc_hd__decap_12
X_3951_ _0904_ VGND VGND VPWR VPWR _0093_ sky130_fd_sc_hd__clkbuf_1
XFILLER_0_58_533 VGND VGND VPWR VPWR sky130_fd_sc_hd__decap_8
XFILLER_0_42_21 VGND VGND VPWR VPWR sky130_fd_sc_hd__decap_6
X_2902_ _0004_ fifo2.mem\[14\]\[3\] _0005_ VGND VGND VPWR VPWR _1607_ sky130_fd_sc_hd__o21a_1
XFILLER_0_42_65 VPWR VGND VPWR VGND sky130_ef_sc_hd__decap_12
X_3882_ _0628_ _0719_ _0721_ VGND VGND VPWR VPWR _0858_ sky130_fd_sc_hd__and3_2
X_2833_ _0004_ VGND VGND VPWR VPWR _1539_ sky130_fd_sc_hd__buf_4
X_2764_ _0732_ _1494_ _1495_ net314 VGND VGND VPWR VPWR _0414_ sky130_fd_sc_hd__a22o_1
XFILLER_0_84_7 VGND VGND VPWR VPWR sky130_fd_sc_hd__fill_1
X_4503_ clknet_leaf_41_clock _0309_ VGND VGND VPWR VPWR fifo2.mem\[10\]\[4\] sky130_fd_sc_hd__dfxtp_1
XFILLER_0_53_293 VPWR VGND VPWR VGND sky130_ef_sc_hd__decap_12
X_2695_ _1467_ _1438_ _0722_ fifo2.mem\[2\]\[7\] _1451_ VGND VGND VPWR VPWR _1475_
+ sky130_fd_sc_hd__o311a_1
X_4434_ clknet_leaf_13_clock _0240_ VGND VGND VPWR VPWR fifo1.mem\[3\]\[1\] sky130_fd_sc_hd__dfxtp_1
XFILLER_0_6_65 VPWR VGND VPWR VGND sky130_ef_sc_hd__decap_12
XFILLER_0_21_190 VGND VGND VPWR VPWR sky130_fd_sc_hd__fill_1
X_4365_ clknet_leaf_21_clock _0179_ VGND VGND VPWR VPWR fifo2.mem\[15\]\[3\] sky130_fd_sc_hd__dfxtp_1
XTAP_341 VGND VPWR sky130_fd_sc_hd__tapvpwrvgnd_1
XTAP_330 VGND VPWR sky130_fd_sc_hd__tapvpwrvgnd_1
X_3316_ _1834_ VGND VGND VPWR VPWR _1942_ sky130_fd_sc_hd__clkbuf_4
XTAP_363 VGND VPWR sky130_fd_sc_hd__tapvpwrvgnd_1
XTAP_352 VGND VPWR sky130_fd_sc_hd__tapvpwrvgnd_1
XTAP_374 VGND VPWR sky130_fd_sc_hd__tapvpwrvgnd_1
XTAP_385 VGND VPWR sky130_fd_sc_hd__tapvpwrvgnd_1
X_4296_ clknet_leaf_0_clock _0110_ VGND VGND VPWR VPWR fifo3.mem\[5\]\[5\] sky130_fd_sc_hd__dfxtp_1
XTAP_396 VGND VPWR sky130_fd_sc_hd__tapvpwrvgnd_1
X_3247_ _1874_ _1864_ _1875_ VGND VGND VPWR VPWR _1876_ sky130_fd_sc_hd__a21oi_1
X_3178_ _1808_ _1809_ VGND VGND VPWR VPWR _1810_ sky130_fd_sc_hd__and2_1
X_2129_ net320 _1091_ _1093_ _0934_ VGND VGND VPWR VPWR _0181_ sky130_fd_sc_hd__a22o_1
XPHY_36 VGND VGND VPWR VPWR sky130_fd_sc_hd__decap_3
XPHY_25 VGND VGND VPWR VPWR sky130_fd_sc_hd__decap_3
XPHY_14 VGND VGND VPWR VPWR sky130_fd_sc_hd__decap_3
XPHY_47 VGND VGND VPWR VPWR sky130_fd_sc_hd__decap_3
XPHY_58 VGND VGND VPWR VPWR sky130_fd_sc_hd__decap_3
XPHY_69 VGND VGND VPWR VPWR sky130_fd_sc_hd__decap_3
XFILLER_0_76_363 VGND VGND VPWR VPWR sky130_fd_sc_hd__fill_1
XFILLER_0_86_149 VGND VGND VPWR VPWR sky130_fd_sc_hd__decap_4
XFILLER_0_67_341 VGND VGND VPWR VPWR sky130_fd_sc_hd__fill_1
XFILLER_0_82_333 VPWR VGND VPWR VGND sky130_ef_sc_hd__decap_12
XFILLER_0_82_377 VGND VGND VPWR VPWR sky130_fd_sc_hd__decap_4
X_2480_ _1360_ _1362_ _1187_ VGND VGND VPWR VPWR _1363_ sky130_fd_sc_hd__a21oi_1
XFILLER_0_2_349 VPWR VGND VPWR VGND sky130_ef_sc_hd__decap_12
XFILLER_0_23_488 VPWR VGND VPWR VGND sky130_ef_sc_hd__decap_12
X_4150_ _0681_ _0648_ fsm1.laf_state VGND VGND VPWR VPWR _1039_ sky130_fd_sc_hd__a21oi_1
X_3101_ fifo3.wr_pointer\[3\] _0784_ VGND VGND VPWR VPWR _1773_ sky130_fd_sc_hd__nand2_2
X_4081_ _0985_ VGND VGND VPWR VPWR _0986_ sky130_fd_sc_hd__buf_2
X_3032_ _1726_ _1728_ _1730_ _1732_ VGND VGND VPWR VPWR _1733_ sky130_fd_sc_hd__a22oi_2
XFILLER_0_77_127 VGND VGND VPWR VPWR sky130_fd_sc_hd__fill_2
XFILLER_0_58_352 VGND VGND VPWR VPWR sky130_fd_sc_hd__decap_4
X_3934_ net11 net41 _0693_ VGND VGND VPWR VPWR _0893_ sky130_fd_sc_hd__and3b_1
XFILLER_0_46_525 VGND VGND VPWR VPWR sky130_fd_sc_hd__decap_6
XFILLER_0_85_193 VGND VGND VPWR VPWR sky130_fd_sc_hd__decap_4
XFILLER_0_73_333 VGND VGND VPWR VPWR sky130_fd_sc_hd__decap_3
X_3865_ _0761_ _0825_ _0830_ _0846_ VGND VGND VPWR VPWR _0065_ sky130_fd_sc_hd__a31o_1
X_2816_ fifo1.mem\[12\]\[1\] fifo1.mem\[13\]\[1\] fifo1.mem\[14\]\[1\] fifo1.mem\[15\]\[1\]
+ _1317_ _1339_ VGND VGND VPWR VPWR _1529_ sky130_fd_sc_hd__mux4_1
XFILLER_0_5_154 VPWR VGND VPWR VGND sky130_ef_sc_hd__decap_12
X_3796_ _0785_ _0789_ fifo3.mem\[7\]\[5\] VGND VGND VPWR VPWR _0794_ sky130_fd_sc_hd__and3_1
X_2747_ _0768_ _1488_ _1489_ net271 VGND VGND VPWR VPWR _0403_ sky130_fd_sc_hd__a22o_1
X_2678_ _1109_ _1465_ _1466_ net166 VGND VGND VPWR VPWR _0357_ sky130_fd_sc_hd__a22o_1
XFILLER_0_78_50 VGND VGND VPWR VPWR sky130_fd_sc_hd__decap_8
XFILLER_0_75_3 VPWR VGND VPWR VGND sky130_ef_sc_hd__decap_12
XFILLER_0_14_477 VGND VGND VPWR VPWR sky130_fd_sc_hd__decap_4
XFILLER_0_78_83 VGND VGND VPWR VPWR sky130_fd_sc_hd__fill_1
X_4417_ clknet_leaf_6_clock _0231_ VGND VGND VPWR VPWR fifo1.mem\[6\]\[1\] sky130_fd_sc_hd__dfxtp_1
XFILLER_0_1_393 VPWR VGND VPWR VGND sky130_ef_sc_hd__decap_12
X_4348_ clknet_leaf_44_clock _0162_ VGND VGND VPWR VPWR regis.internal_parity\[3\]
+ sky130_fd_sc_hd__dfxtp_1
X_4279_ clknet_leaf_47_clock _0093_ VGND VGND VPWR VPWR syn.count2\[3\] sky130_fd_sc_hd__dfxtp_1
XTAP_193 VGND VPWR sky130_fd_sc_hd__tapvpwrvgnd_1
XFILLER_0_83_108 VGND VGND VPWR VPWR sky130_fd_sc_hd__decap_4
XFILLER_0_91_141 VPWR VGND VPWR VGND sky130_ef_sc_hd__decap_12
XFILLER_0_52_528 VGND VGND VPWR VPWR sky130_fd_sc_hd__fill_1
XFILLER_0_90_29 VPWR VGND VPWR VGND sky130_ef_sc_hd__decap_12
XFILLER_0_28_525 VGND VGND VPWR VPWR sky130_fd_sc_hd__decap_6
XFILLER_0_55_377 VGND VGND VPWR VPWR sky130_fd_sc_hd__decap_6
X_3650_ _0683_ VGND VGND VPWR VPWR _0015_ sky130_fd_sc_hd__clkbuf_1
XFILLER_0_70_336 VGND VGND VPWR VPWR sky130_fd_sc_hd__fill_1
X_3581_ fifo2.wr_pointer\[2\] VGND VGND VPWR VPWR _0619_ sky130_fd_sc_hd__clkbuf_4
X_2601_ _0729_ VGND VGND VPWR VPWR _1437_ sky130_fd_sc_hd__clkbuf_4
X_2532_ _1409_ _1410_ _0874_ VGND VGND VPWR VPWR _1411_ sky130_fd_sc_hd__and3_1
XFILLER_0_61_9 VPWR VGND VPWR VGND sky130_ef_sc_hd__decap_12
X_4202_ regis.packet_parity\[7\] regis.internal_parity\[7\] VGND VGND VPWR VPWR _1074_
+ sky130_fd_sc_hd__or2_1
X_2463_ fifo1.mem\[4\]\[6\] fifo1.mem\[5\]\[6\] fifo1.mem\[6\]\[6\] fifo1.mem\[7\]\[6\]
+ _1189_ _1183_ VGND VGND VPWR VPWR _1347_ sky130_fd_sc_hd__mux4_1
X_2394_ _1276_ _1277_ _1278_ _1279_ VGND VGND VPWR VPWR _1280_ sky130_fd_sc_hd__o22ai_2
X_4133_ _1029_ VGND VGND VPWR VPWR _0150_ sky130_fd_sc_hd__clkbuf_1
XFILLER_0_3_55 VGND VGND VPWR VPWR sky130_fd_sc_hd__fill_1
X_4064_ _0733_ _0859_ _0972_ VGND VGND VPWR VPWR _0977_ sky130_fd_sc_hd__and3_1
XFILLER_0_78_403 VGND VGND VPWR VPWR sky130_fd_sc_hd__fill_1
X_3015_ _1713_ _1716_ VGND VGND VPWR VPWR _1717_ sky130_fd_sc_hd__nand2_1
XFILLER_0_19_503 VGND VGND VPWR VPWR sky130_fd_sc_hd__fill_1
X_3917_ syn.count1\[0\] syn.count1\[1\] VGND VGND VPWR VPWR _0880_ sky130_fd_sc_hd__xnor2_1
XFILLER_0_34_517 VPWR VGND VPWR VGND sky130_ef_sc_hd__decap_12
XFILLER_0_6_452 VGND VGND VPWR VPWR sky130_fd_sc_hd__fill_1
X_3848_ _0769_ VGND VGND VPWR VPWR _0833_ sky130_fd_sc_hd__clkbuf_4
X_3779_ _0781_ VGND VGND VPWR VPWR _0782_ sky130_fd_sc_hd__buf_2
XFILLER_0_89_93 VPWR VGND VPWR VGND sky130_ef_sc_hd__decap_12
XFILLER_0_14_274 VGND VGND VPWR VPWR sky130_fd_sc_hd__fill_1
Xclkbuf_leaf_41_clock clknet_3_5__leaf_clock VGND VGND VPWR VPWR clknet_leaf_41_clock
+ sky130_fd_sc_hd__clkbuf_16
Xclkbuf_leaf_56_clock clknet_3_1__leaf_clock VGND VGND VPWR VPWR clknet_leaf_56_clock
+ sky130_fd_sc_hd__clkbuf_16
XFILLER_0_84_417 VGND VGND VPWR VPWR sky130_fd_sc_hd__decap_3
XFILLER_0_37_311 VGND VGND VPWR VPWR sky130_fd_sc_hd__fill_1
XFILLER_0_25_517 VGND VGND VPWR VPWR sky130_fd_sc_hd__decap_6
XFILLER_0_64_141 VGND VGND VPWR VPWR sky130_fd_sc_hd__decap_8
XFILLER_0_25_539 VGND VGND VPWR VPWR sky130_fd_sc_hd__fill_2
XFILLER_0_37_399 VGND VGND VPWR VPWR sky130_fd_sc_hd__fill_1
XFILLER_0_60_391 VGND VGND VPWR VPWR sky130_fd_sc_hd__decap_8
XTAP_907 VGND VPWR sky130_fd_sc_hd__tapvpwrvgnd_1
XTAP_929 VGND VPWR sky130_fd_sc_hd__tapvpwrvgnd_1
XTAP_918 VGND VPWR sky130_fd_sc_hd__tapvpwrvgnd_1
XFILLER_0_18_45 VGND VGND VPWR VPWR sky130_fd_sc_hd__decap_8
XFILLER_0_75_417 VPWR VGND VPWR VGND sky130_ef_sc_hd__decap_12
XFILLER_0_34_77 VGND VGND VPWR VPWR sky130_fd_sc_hd__decap_6
XFILLER_0_83_461 VPWR VGND VPWR VGND sky130_ef_sc_hd__decap_12
X_4751_ clknet_leaf_53_clock _0557_ VGND VGND VPWR VPWR fifo3.mem\[0\]\[6\] sky130_fd_sc_hd__dfxtp_1
XFILLER_0_16_517 VPWR VGND VPWR VGND sky130_ef_sc_hd__decap_12
X_4682_ clknet_leaf_59_clock _0488_ VGND VGND VPWR VPWR fifo3.mem\[4\]\[5\] sky130_fd_sc_hd__dfxtp_1
XFILLER_0_50_65 VGND VGND VPWR VPWR sky130_fd_sc_hd__decap_4
X_3702_ _0716_ _0722_ VGND VGND VPWR VPWR _0723_ sky130_fd_sc_hd__nor2_2
X_3633_ _0666_ net41 net42 _0667_ _0668_ VGND VGND VPWR VPWR _0669_ sky130_fd_sc_hd__o221a_1
XFILLER_0_70_155 VGND VGND VPWR VPWR sky130_fd_sc_hd__fill_1
X_3564_ _0765_ _1753_ _0920_ _2106_ net69 VGND VGND VPWR VPWR _0603_ sky130_fd_sc_hd__a32o_1
X_2515_ _1395_ _1396_ _1195_ VGND VGND VPWR VPWR _1397_ sky130_fd_sc_hd__o21bai_1
X_3495_ _0725_ _0728_ _0872_ _0729_ VGND VGND VPWR VPWR _2081_ sky130_fd_sc_hd__o31a_2
XFILLER_0_59_74 VGND VGND VPWR VPWR sky130_fd_sc_hd__decap_8
X_2446_ _1195_ _1329_ VGND VGND VPWR VPWR _1330_ sky130_fd_sc_hd__or2b_1
X_4116_ fifo1.lfd_state fifo1.data_in\[5\] VGND VGND VPWR VPWR _1016_ sky130_fd_sc_hd__or2b_1
XFILLER_0_38_3 VPWR VGND VPWR VGND sky130_ef_sc_hd__decap_12
X_2377_ fifo1.mem\[5\]\[4\] _1232_ VGND VGND VPWR VPWR _1263_ sky130_fd_sc_hd__and2b_1
XFILLER_0_78_211 VGND VGND VPWR VPWR sky130_fd_sc_hd__decap_4
X_4047_ _0762_ _0960_ _0956_ _0966_ VGND VGND VPWR VPWR _0127_ sky130_fd_sc_hd__a31o_1
XFILLER_0_91_83 VGND VGND VPWR VPWR sky130_fd_sc_hd__fill_1
XFILLER_0_78_266 VGND VGND VPWR VPWR sky130_fd_sc_hd__fill_1
XFILLER_0_66_417 VGND VGND VPWR VPWR sky130_fd_sc_hd__decap_3
XFILLER_0_78_299 VGND VGND VPWR VPWR sky130_fd_sc_hd__decap_8
XFILLER_0_61_122 VGND VGND VPWR VPWR sky130_fd_sc_hd__fill_1
XFILLER_0_61_133 VGND VGND VPWR VPWR sky130_fd_sc_hd__decap_4
XFILLER_0_6_293 VPWR VGND VPWR VGND sky130_ef_sc_hd__decap_12
XFILLER_0_30_531 VGND VGND VPWR VPWR sky130_fd_sc_hd__fill_1
XFILLER_0_29_119 VGND VGND VPWR VPWR sky130_fd_sc_hd__fill_1
XFILLER_0_25_314 VGND VGND VPWR VPWR sky130_fd_sc_hd__fill_1
XFILLER_0_65_461 VGND VGND VPWR VPWR sky130_fd_sc_hd__fill_1
XFILLER_0_80_475 VGND VGND VPWR VPWR sky130_fd_sc_hd__fill_1
XFILLER_0_20_68 VPWR VGND VPWR VGND sky130_ef_sc_hd__decap_12
XFILLER_0_40_317 VGND VGND VPWR VPWR sky130_fd_sc_hd__decap_8
X_3280_ fifo3.mem\[3\]\[4\] _1838_ _1907_ VGND VGND VPWR VPWR _1908_ sky130_fd_sc_hd__o21ai_1
XTAP_704 VGND VPWR sky130_fd_sc_hd__tapvpwrvgnd_1
XTAP_715 VGND VPWR sky130_fd_sc_hd__tapvpwrvgnd_1
X_2300_ _0000_ VGND VGND VPWR VPWR _1188_ sky130_fd_sc_hd__clkbuf_4
XFILLER_0_29_77 VPWR VGND VPWR VGND sky130_ef_sc_hd__decap_12
X_2231_ net298 _1137_ _1139_ _0938_ VGND VGND VPWR VPWR _0237_ sky130_fd_sc_hd__a22o_1
XTAP_726 VGND VPWR sky130_fd_sc_hd__tapvpwrvgnd_1
XTAP_737 VGND VPWR sky130_fd_sc_hd__tapvpwrvgnd_1
XTAP_748 VGND VPWR sky130_fd_sc_hd__tapvpwrvgnd_1
XTAP_759 VGND VPWR sky130_fd_sc_hd__tapvpwrvgnd_1
X_2162_ _0742_ VGND VGND VPWR VPWR _1108_ sky130_fd_sc_hd__clkbuf_4
XFILLER_0_24_9 VPWR VGND VPWR VGND sky130_ef_sc_hd__decap_12
XFILLER_0_45_54 VGND VGND VPWR VPWR sky130_fd_sc_hd__fill_2
XFILLER_0_88_531 VGND VGND VPWR VPWR sky130_fd_sc_hd__fill_1
XFILLER_0_75_225 VPWR VGND VPWR VGND sky130_ef_sc_hd__decap_12
XFILLER_0_28_141 VGND VGND VPWR VPWR sky130_fd_sc_hd__fill_2
XFILLER_0_61_53 VGND VGND VPWR VPWR sky130_fd_sc_hd__decap_3
XFILLER_0_61_86 VGND VGND VPWR VPWR sky130_fd_sc_hd__decap_8
X_4734_ clknet_leaf_52_clock _0540_ VGND VGND VPWR VPWR fifo3.count\[0\] sky130_fd_sc_hd__dfxtp_1
X_2995_ _1696_ _1691_ _1625_ VGND VGND VPWR VPWR _1697_ sky130_fd_sc_hd__nand3_1
XFILLER_0_16_336 VPWR VGND VPWR VGND sky130_ef_sc_hd__decap_12
XFILLER_0_28_185 VGND VGND VPWR VPWR sky130_fd_sc_hd__decap_3
XFILLER_0_43_111 VGND VGND VPWR VPWR sky130_fd_sc_hd__fill_1
XFILLER_0_43_133 VGND VGND VPWR VPWR sky130_fd_sc_hd__fill_1
X_4665_ clknet_leaf_2_clock _0471_ VGND VGND VPWR VPWR fifo3.mem\[2\]\[6\] sky130_fd_sc_hd__dfxtp_1
X_3616_ _0653_ VGND VGND VPWR VPWR _0654_ sky130_fd_sc_hd__clkbuf_2
X_4596_ clknet_leaf_10_clock _0402_ VGND VGND VPWR VPWR fifo1.mem\[10\]\[7\] sky130_fd_sc_hd__dfxtp_1
X_3547_ _1753_ VGND VGND VPWR VPWR _2105_ sky130_fd_sc_hd__buf_2
X_3478_ _0712_ _2070_ net45 VGND VGND VPWR VPWR _2073_ sky130_fd_sc_hd__and3_1
X_2429_ _1310_ _1311_ _1312_ _1313_ VGND VGND VPWR VPWR _1314_ sky130_fd_sc_hd__o2bb2ai_1
XFILLER_0_66_203 VGND VGND VPWR VPWR sky130_fd_sc_hd__fill_1
XFILLER_0_81_206 VPWR VGND VPWR VGND sky130_ef_sc_hd__decap_12
XFILLER_0_22_317 VGND VGND VPWR VPWR sky130_fd_sc_hd__fill_2
XFILLER_0_34_188 VGND VGND VPWR VPWR sky130_fd_sc_hd__decap_8
XFILLER_0_30_394 VGND VGND VPWR VPWR sky130_fd_sc_hd__decap_8
XFILLER_0_89_317 VPWR VGND VPWR VGND sky130_ef_sc_hd__decap_12
XFILLER_0_57_225 VGND VGND VPWR VPWR sky130_fd_sc_hd__decap_8
XFILLER_0_72_217 VPWR VGND VPWR VGND sky130_ef_sc_hd__decap_12
XFILLER_0_5_517 VPWR VGND VPWR VGND sky130_ef_sc_hd__decap_12
XFILLER_0_25_133 VGND VGND VPWR VPWR sky130_fd_sc_hd__decap_4
XFILLER_0_31_45 VGND VGND VPWR VPWR sky130_fd_sc_hd__decap_3
X_2780_ _1093_ _1091_ fifo2.wr_pointer\[4\] VGND VGND VPWR VPWR _1500_ sky130_fd_sc_hd__mux2_1
XFILLER_0_25_155 VGND VGND VPWR VPWR sky130_fd_sc_hd__fill_2
Xhold207 fifo3.mem\[12\]\[4\] VGND VGND VPWR VPWR net255 sky130_fd_sc_hd__dlygate4sd3_1
X_4450_ clknet_leaf_20_clock _0256_ VGND VGND VPWR VPWR fifo1.rd_pointer\[3\] sky130_fd_sc_hd__dfxtp_1
X_3401_ _2007_ VGND VGND VPWR VPWR _0539_ sky130_fd_sc_hd__clkbuf_1
Xhold229 fifo1.mem\[12\]\[5\] VGND VGND VPWR VPWR net277 sky130_fd_sc_hd__dlygate4sd3_1
X_4381_ clknet_leaf_5_clock _0195_ VGND VGND VPWR VPWR fifo1.mem\[5\]\[1\] sky130_fd_sc_hd__dfxtp_1
Xhold218 fifo1.mem\[8\]\[8\] VGND VGND VPWR VPWR net266 sky130_fd_sc_hd__dlygate4sd3_1
XFILLER_0_21_372 VPWR VGND VPWR VGND sky130_ef_sc_hd__decap_12
X_3332_ _1955_ _1957_ _1812_ VGND VGND VPWR VPWR _1958_ sky130_fd_sc_hd__a21o_1
XTAP_501 VGND VPWR sky130_fd_sc_hd__tapvpwrvgnd_1
XTAP_512 VGND VPWR sky130_fd_sc_hd__tapvpwrvgnd_1
XTAP_523 VGND VPWR sky130_fd_sc_hd__tapvpwrvgnd_1
XTAP_534 VGND VPWR sky130_fd_sc_hd__tapvpwrvgnd_1
X_3263_ _1878_ _0874_ _1891_ VGND VGND VPWR VPWR _1892_ sky130_fd_sc_hd__and3_1
XTAP_545 VGND VPWR sky130_fd_sc_hd__tapvpwrvgnd_1
XTAP_556 VGND VPWR sky130_fd_sc_hd__tapvpwrvgnd_1
XTAP_567 VGND VPWR sky130_fd_sc_hd__tapvpwrvgnd_1
X_3194_ fifo3.mem\[8\]\[1\] fifo3.mem\[9\]\[1\] fifo3.mem\[10\]\[1\] fifo3.mem\[11\]\[1\]
+ _1805_ _1807_ VGND VGND VPWR VPWR _1825_ sky130_fd_sc_hd__mux4_1
XTAP_578 VGND VPWR sky130_fd_sc_hd__tapvpwrvgnd_1
XTAP_589 VGND VPWR sky130_fd_sc_hd__tapvpwrvgnd_1
X_2214_ _1126_ _1119_ fifo1.mem\[7\]\[6\] VGND VGND VPWR VPWR _1133_ sky130_fd_sc_hd__and3_1
XFILLER_0_56_53 VGND VGND VPWR VPWR sky130_fd_sc_hd__decap_4
X_2145_ _0766_ _1096_ _1097_ net280 VGND VGND VPWR VPWR _0192_ sky130_fd_sc_hd__a22o_1
XFILLER_0_72_85 VGND VGND VPWR VPWR sky130_fd_sc_hd__decap_3
X_2978_ _1567_ fifo2.mem\[14\]\[5\] _1570_ VGND VGND VPWR VPWR _1681_ sky130_fd_sc_hd__o21a_1
X_4717_ clknet_leaf_53_clock _0523_ VGND VGND VPWR VPWR fifo3.wr_pointer\[1\] sky130_fd_sc_hd__dfxtp_1
X_4648_ clknet_leaf_24_clock _0454_ VGND VGND VPWR VPWR fifo2.mem\[6\]\[7\] sky130_fd_sc_hd__dfxtp_1
XFILLER_0_16_177 VGND VGND VPWR VPWR sky130_fd_sc_hd__fill_2
XFILLER_0_12_350 VPWR VGND VPWR VGND sky130_ef_sc_hd__decap_12
X_4579_ clknet_leaf_48_clock _0385_ VGND VGND VPWR VPWR fifo3.mem\[15\]\[8\] sky130_fd_sc_hd__dfxtp_1
XFILLER_0_79_383 VGND VGND VPWR VPWR sky130_fd_sc_hd__fill_1
XFILLER_0_79_372 VGND VGND VPWR VPWR sky130_fd_sc_hd__decap_4
XFILLER_0_39_225 VPWR VGND VPWR VGND sky130_ef_sc_hd__decap_12
Xclkbuf_3_3__f_clock clknet_0_clock VGND VGND VPWR VPWR clknet_3_3__leaf_clock sky130_fd_sc_hd__clkbuf_16
XFILLER_0_50_489 VGND VGND VPWR VPWR sky130_fd_sc_hd__fill_1
XFILLER_0_89_125 VPWR VGND VPWR VGND sky130_ef_sc_hd__decap_12
Xhold90 fifo3.mem\[15\]\[8\] VGND VGND VPWR VPWR net138 sky130_fd_sc_hd__dlygate4sd3_1
XFILLER_0_89_169 VGND VGND VPWR VPWR sky130_fd_sc_hd__decap_4
XFILLER_0_77_309 VGND VGND VPWR VPWR sky130_fd_sc_hd__fill_1
XFILLER_0_58_501 VGND VGND VPWR VPWR sky130_fd_sc_hd__decap_8
X_3950_ _0902_ _0898_ _0903_ VGND VGND VPWR VPWR _0904_ sky130_fd_sc_hd__and3b_1
XFILLER_0_58_512 VGND VGND VPWR VPWR sky130_fd_sc_hd__decap_8
XFILLER_0_9_119 VGND VGND VPWR VPWR sky130_fd_sc_hd__decap_4
X_2901_ _1569_ fifo2.mem\[12\]\[3\] _1570_ VGND VGND VPWR VPWR _1606_ sky130_fd_sc_hd__o21bai_1
XFILLER_0_42_77 VGND VGND VPWR VPWR sky130_fd_sc_hd__decap_6
X_3881_ _0851_ VGND VGND VPWR VPWR _0857_ sky130_fd_sc_hd__clkbuf_4
XFILLER_0_45_206 VPWR VGND VPWR VGND sky130_ef_sc_hd__decap_12
X_2832_ _1537_ VGND VGND VPWR VPWR _1538_ sky130_fd_sc_hd__clkbuf_4
X_2763_ _1110_ _1494_ _1495_ net206 VGND VGND VPWR VPWR _0413_ sky130_fd_sc_hd__a22o_1
X_4502_ clknet_leaf_39_clock _0308_ VGND VGND VPWR VPWR fifo2.mem\[10\]\[3\] sky130_fd_sc_hd__dfxtp_1
X_2694_ _0764_ _0724_ _1436_ _1474_ VGND VGND VPWR VPWR _0365_ sky130_fd_sc_hd__a31o_1
X_4433_ clknet_leaf_12_clock _0239_ VGND VGND VPWR VPWR fifo1.mem\[3\]\[0\] sky130_fd_sc_hd__dfxtp_1
X_4364_ clknet_leaf_37_clock _0178_ VGND VGND VPWR VPWR fifo2.mem\[15\]\[2\] sky130_fd_sc_hd__dfxtp_1
XTAP_342 VGND VPWR sky130_fd_sc_hd__tapvpwrvgnd_1
XTAP_331 VGND VPWR sky130_fd_sc_hd__tapvpwrvgnd_1
XTAP_320 VGND VPWR sky130_fd_sc_hd__tapvpwrvgnd_1
XFILLER_0_6_77 VGND VGND VPWR VPWR sky130_fd_sc_hd__decap_6
X_4295_ clknet_leaf_0_clock _0109_ VGND VGND VPWR VPWR fifo3.mem\[5\]\[4\] sky130_fd_sc_hd__dfxtp_1
X_3315_ _1814_ _1923_ _1929_ _1941_ _0996_ VGND VGND VPWR VPWR _0519_ sky130_fd_sc_hd__o311a_1
XTAP_364 VGND VPWR sky130_fd_sc_hd__tapvpwrvgnd_1
XTAP_353 VGND VPWR sky130_fd_sc_hd__tapvpwrvgnd_1
XTAP_375 VGND VPWR sky130_fd_sc_hd__tapvpwrvgnd_1
X_3246_ _1849_ fifo3.mem\[2\]\[3\] _1806_ VGND VGND VPWR VPWR _1875_ sky130_fd_sc_hd__o21ai_1
XTAP_386 VGND VPWR sky130_fd_sc_hd__tapvpwrvgnd_1
XTAP_397 VGND VPWR sky130_fd_sc_hd__tapvpwrvgnd_1
X_3177_ _0010_ VGND VGND VPWR VPWR _1809_ sky130_fd_sc_hd__clkbuf_4
XFILLER_0_20_3 VPWR VGND VPWR VGND sky130_ef_sc_hd__decap_12
X_2128_ net267 _1091_ _1093_ _0932_ VGND VGND VPWR VPWR _0180_ sky130_fd_sc_hd__a22o_1
XFILLER_0_68_309 VGND VGND VPWR VPWR sky130_fd_sc_hd__decap_6
XPHY_26 VGND VGND VPWR VPWR sky130_fd_sc_hd__decap_3
XPHY_15 VGND VGND VPWR VPWR sky130_fd_sc_hd__decap_3
XPHY_37 VGND VGND VPWR VPWR sky130_fd_sc_hd__decap_3
XPHY_48 VGND VGND VPWR VPWR sky130_fd_sc_hd__decap_3
XPHY_59 VGND VGND VPWR VPWR sky130_fd_sc_hd__decap_3
XFILLER_0_44_294 VPWR VGND VPWR VGND sky130_ef_sc_hd__decap_12
XFILLER_0_86_139 VGND VGND VPWR VPWR sky130_fd_sc_hd__fill_1
XFILLER_0_82_345 VPWR VGND VPWR VGND sky130_ef_sc_hd__decap_12
XFILLER_0_82_389 VGND VGND VPWR VPWR sky130_fd_sc_hd__decap_8
XFILLER_0_88_29 VPWR VGND VPWR VGND sky130_ef_sc_hd__decap_12
XFILLER_0_50_231 VGND VGND VPWR VPWR sky130_fd_sc_hd__decap_4
X_3100_ _0770_ VGND VGND VPWR VPWR _1772_ sky130_fd_sc_hd__clkbuf_4
X_4080_ _0678_ _0681_ VGND VGND VPWR VPWR _0985_ sky130_fd_sc_hd__and2_1
X_3031_ _1547_ _1731_ _1538_ VGND VGND VPWR VPWR _1732_ sky130_fd_sc_hd__a21oi_1
XFILLER_0_53_54 VGND VGND VPWR VPWR sky130_fd_sc_hd__fill_2
X_3933_ syn.count1\[5\] syn.count1\[4\] _0884_ syn.count1\[3\] VGND VGND VPWR VPWR
+ _0892_ sky130_fd_sc_hd__and4b_1
XFILLER_0_18_206 VGND VGND VPWR VPWR sky130_fd_sc_hd__fill_2
XFILLER_0_73_345 VGND VGND VPWR VPWR sky130_fd_sc_hd__decap_4
X_3864_ _0832_ _0840_ _0841_ _0844_ fifo3.mem\[1\]\[3\] VGND VGND VPWR VPWR _0846_
+ sky130_fd_sc_hd__o311a_1
XFILLER_0_58_397 VGND VGND VPWR VPWR sky130_fd_sc_hd__decap_4
X_2815_ _1187_ _1527_ _1181_ VGND VGND VPWR VPWR _1528_ sky130_fd_sc_hd__a21o_1
X_3795_ _0762_ _0778_ _0790_ _0793_ VGND VGND VPWR VPWR _0048_ sky130_fd_sc_hd__a31o_1
XFILLER_0_5_188 VGND VGND VPWR VPWR sky130_fd_sc_hd__fill_1
XFILLER_0_5_166 VGND VGND VPWR VPWR sky130_fd_sc_hd__fill_2
X_2746_ _1109_ _1488_ _1489_ net236 VGND VGND VPWR VPWR _0402_ sky130_fd_sc_hd__a22o_1
X_2677_ _1108_ _1465_ _1466_ net126 VGND VGND VPWR VPWR _0356_ sky130_fd_sc_hd__a22o_1
XFILLER_0_1_361 VPWR VGND VPWR VGND sky130_ef_sc_hd__decap_12
X_4416_ clknet_leaf_8_clock _0230_ VGND VGND VPWR VPWR fifo1.mem\[6\]\[0\] sky130_fd_sc_hd__dfxtp_1
XFILLER_0_68_3 VGND VGND VPWR VPWR sky130_fd_sc_hd__fill_2
X_4347_ clknet_leaf_45_clock _0161_ VGND VGND VPWR VPWR regis.internal_parity\[2\]
+ sky130_fd_sc_hd__dfxtp_1
X_4278_ clknet_leaf_47_clock _0092_ VGND VGND VPWR VPWR syn.count2\[2\] sky130_fd_sc_hd__dfxtp_2
XTAP_194 VGND VPWR sky130_fd_sc_hd__tapvpwrvgnd_1
X_3229_ _1856_ _1832_ _1858_ VGND VGND VPWR VPWR _1859_ sky130_fd_sc_hd__a21oi_1
XFILLER_0_68_139 VGND VGND VPWR VPWR sky130_fd_sc_hd__fill_1
XFILLER_0_9_461 VGND VGND VPWR VPWR sky130_fd_sc_hd__fill_1
XFILLER_0_91_153 VPWR VGND VPWR VGND sky130_ef_sc_hd__decap_12
XFILLER_0_91_197 VPWR VGND VPWR VGND sky130_ef_sc_hd__decap_12
XFILLER_0_91_175 VPWR VGND VPWR VGND sky130_ef_sc_hd__decap_12
XFILLER_0_32_297 VGND VGND VPWR VPWR sky130_fd_sc_hd__fill_1
XFILLER_0_7_409 VPWR VGND VPWR VGND sky130_ef_sc_hd__decap_12
XFILLER_0_23_57 VGND VGND VPWR VPWR sky130_fd_sc_hd__decap_3
XFILLER_0_67_194 VPWR VGND VPWR VGND sky130_ef_sc_hd__decap_12
XFILLER_0_82_197 VGND VGND VPWR VPWR sky130_fd_sc_hd__decap_4
X_3580_ fsm1.addr\[1\] fsm1.addr\[0\] VGND VGND VPWR VPWR _0618_ sky130_fd_sc_hd__or2b_2
X_2600_ _1435_ _0867_ fifo2.mem\[10\]\[4\] _0865_ _1426_ VGND VGND VPWR VPWR _0309_
+ sky130_fd_sc_hd__a32o_1
X_2531_ fifo3.rd_pointer\[2\] fifo3.rd_pointer\[1\] _0637_ _1404_ VGND VGND VPWR VPWR
+ _1410_ sky130_fd_sc_hd__nand4_1
X_2462_ _1343_ _1345_ _1200_ VGND VGND VPWR VPWR _1346_ sky130_fd_sc_hd__a21oi_2
X_4201_ regis.packet_parity\[3\] regis.internal_parity\[3\] VGND VGND VPWR VPWR _1073_
+ sky130_fd_sc_hd__nand2_1
X_2393_ fifo1.mem\[15\]\[4\] _1232_ VGND VGND VPWR VPWR _1279_ sky130_fd_sc_hd__and2b_1
X_4132_ _1028_ _0983_ VGND VGND VPWR VPWR _1029_ sky130_fd_sc_hd__and2_1
X_4063_ _0716_ _0726_ _0727_ _0722_ VGND VGND VPWR VPWR _0976_ sky130_fd_sc_hd__or4_2
X_3014_ _1693_ _1715_ VGND VGND VPWR VPWR _1716_ sky130_fd_sc_hd__nand2_1
XFILLER_0_3_89 VGND VGND VPWR VPWR sky130_fd_sc_hd__decap_3
Xwire46 _0829_ VGND VGND VPWR VPWR net46 sky130_fd_sc_hd__buf_1
XFILLER_0_65_109 VGND VGND VPWR VPWR sky130_fd_sc_hd__decap_3
X_3916_ net309 _0879_ VGND VGND VPWR VPWR _0083_ sky130_fd_sc_hd__nor2_1
XFILLER_0_80_63 VGND VGND VPWR VPWR sky130_fd_sc_hd__decap_4
XFILLER_0_73_120 VGND VGND VPWR VPWR sky130_fd_sc_hd__decap_6
XFILLER_0_80_85 VGND VGND VPWR VPWR sky130_fd_sc_hd__decap_4
XFILLER_0_13_90 VGND VGND VPWR VPWR sky130_fd_sc_hd__fill_1
X_3847_ _0823_ _0831_ VGND VGND VPWR VPWR _0832_ sky130_fd_sc_hd__nand2b_4
XFILLER_0_34_529 VGND VGND VPWR VPWR sky130_fd_sc_hd__decap_3
XFILLER_0_61_326 VGND VGND VPWR VPWR sky130_fd_sc_hd__fill_1
X_3778_ _0780_ VGND VGND VPWR VPWR _0781_ sky130_fd_sc_hd__buf_2
XFILLER_0_61_337 VGND VGND VPWR VPWR sky130_fd_sc_hd__fill_1
X_2729_ _1104_ _1485_ _1486_ net275 VGND VGND VPWR VPWR _0388_ sky130_fd_sc_hd__a22o_1
XFILLER_0_77_481 VGND VGND VPWR VPWR sky130_fd_sc_hd__decap_6
XTAP_908 VGND VPWR sky130_fd_sc_hd__tapvpwrvgnd_1
XTAP_919 VGND VPWR sky130_fd_sc_hd__tapvpwrvgnd_1
XFILLER_0_34_45 VGND VGND VPWR VPWR sky130_fd_sc_hd__fill_1
XFILLER_0_75_429 VGND VGND VPWR VPWR sky130_fd_sc_hd__decap_8
XFILLER_0_68_481 VGND VGND VPWR VPWR sky130_fd_sc_hd__decap_8
X_4750_ clknet_leaf_52_clock _0556_ VGND VGND VPWR VPWR fifo3.mem\[0\]\[5\] sky130_fd_sc_hd__dfxtp_1
XFILLER_0_83_473 VPWR VGND VPWR VGND sky130_ef_sc_hd__decap_12
XFILLER_0_16_529 VGND VGND VPWR VPWR sky130_fd_sc_hd__decap_3
X_4681_ clknet_leaf_59_clock _0487_ VGND VGND VPWR VPWR fifo3.mem\[4\]\[4\] sky130_fd_sc_hd__dfxtp_1
XFILLER_0_28_378 VGND VGND VPWR VPWR sky130_fd_sc_hd__fill_2
X_3701_ _0717_ _0628_ _0719_ _0721_ VGND VGND VPWR VPWR _0722_ sky130_fd_sc_hd__nand4_4
X_3632_ _0605_ _0610_ _0616_ net48 VGND VGND VPWR VPWR _0668_ sky130_fd_sc_hd__nand4b_1
XFILLER_0_43_337 VGND VGND VPWR VPWR sky130_fd_sc_hd__fill_2
XFILLER_0_50_77 VGND VGND VPWR VPWR sky130_fd_sc_hd__decap_6
XFILLER_0_50_99 VGND VGND VPWR VPWR sky130_fd_sc_hd__decap_6
X_3563_ _0742_ _1753_ _0920_ _2106_ net83 VGND VGND VPWR VPWR _0602_ sky130_fd_sc_hd__a32o_1
XFILLER_0_11_223 VGND VGND VPWR VPWR sky130_fd_sc_hd__fill_1
X_2514_ _1156_ _1157_ _1259_ VGND VGND VPWR VPWR _1396_ sky130_fd_sc_hd__and3_1
XFILLER_0_11_256 VGND VGND VPWR VPWR sky130_fd_sc_hd__decap_3
X_3494_ _0767_ _2070_ _0837_ _2074_ net209 VGND VGND VPWR VPWR _0559_ sky130_fd_sc_hd__a32o_1
X_2445_ net10 net40 _1328_ _1291_ fifo1.count\[4\] VGND VGND VPWR VPWR _1329_ sky130_fd_sc_hd__a32o_1
X_4115_ net6 _0986_ _0989_ _1014_ VGND VGND VPWR VPWR _1015_ sky130_fd_sc_hd__o211ai_1
X_2376_ _1189_ fifo1.mem\[4\]\[4\] _1182_ VGND VGND VPWR VPWR _1262_ sky130_fd_sc_hd__o21bai_1
X_4046_ _0957_ _0961_ _0962_ fifo2.mem\[1\]\[4\] _0963_ VGND VGND VPWR VPWR _0966_
+ sky130_fd_sc_hd__o311a_1
XFILLER_0_46_186 VGND VGND VPWR VPWR sky130_fd_sc_hd__fill_2
XFILLER_0_29_109 VGND VGND VPWR VPWR sky130_fd_sc_hd__decap_3
XFILLER_0_52_101 VPWR VGND VPWR VGND sky130_ef_sc_hd__decap_12
XFILLER_0_80_421 VGND VGND VPWR VPWR sky130_fd_sc_hd__decap_6
XFILLER_0_33_370 VPWR VGND VPWR VGND sky130_ef_sc_hd__decap_12
XTAP_705 VGND VPWR sky130_fd_sc_hd__tapvpwrvgnd_1
XTAP_716 VGND VPWR sky130_fd_sc_hd__tapvpwrvgnd_1
X_2230_ net257 _1137_ _1139_ _0936_ VGND VGND VPWR VPWR _0236_ sky130_fd_sc_hd__a22o_1
XTAP_727 VGND VPWR sky130_fd_sc_hd__tapvpwrvgnd_1
XTAP_738 VGND VPWR sky130_fd_sc_hd__tapvpwrvgnd_1
XTAP_749 VGND VPWR sky130_fd_sc_hd__tapvpwrvgnd_1
X_2161_ _1107_ _1101_ _1103_ net270 VGND VGND VPWR VPWR _0199_ sky130_fd_sc_hd__a22o_1
XFILLER_0_17_9 VGND VGND VPWR VPWR sky130_fd_sc_hd__fill_2
Xclkbuf_leaf_40_clock clknet_3_5__leaf_clock VGND VGND VPWR VPWR clknet_leaf_40_clock
+ sky130_fd_sc_hd__clkbuf_16
XFILLER_0_48_407 VGND VGND VPWR VPWR sky130_fd_sc_hd__fill_2
XFILLER_0_75_237 VGND VGND VPWR VPWR sky130_fd_sc_hd__decap_6
XFILLER_0_0_57 VPWR VGND VPWR VGND sky130_ef_sc_hd__decap_12
XFILLER_0_61_21 VPWR VGND VPWR VGND sky130_ef_sc_hd__decap_12
X_2994_ _1683_ _1542_ VGND VGND VPWR VPWR _1696_ sky130_fd_sc_hd__nand2_1
X_4733_ clknet_leaf_26_clock _0539_ VGND VGND VPWR VPWR net30 sky130_fd_sc_hd__dfxtp_1
Xclkbuf_leaf_55_clock clknet_3_1__leaf_clock VGND VGND VPWR VPWR clknet_leaf_55_clock
+ sky130_fd_sc_hd__clkbuf_16
XFILLER_0_16_348 VPWR VGND VPWR VGND sky130_ef_sc_hd__decap_12
XFILLER_0_9_55 VGND VGND VPWR VPWR sky130_fd_sc_hd__fill_1
XFILLER_0_31_307 VGND VGND VPWR VPWR sky130_fd_sc_hd__fill_1
X_4664_ clknet_leaf_2_clock _0470_ VGND VGND VPWR VPWR fifo3.mem\[2\]\[5\] sky130_fd_sc_hd__dfxtp_1
X_3615_ _0650_ _0651_ _0652_ VGND VGND VPWR VPWR _0653_ sky130_fd_sc_hd__and3_1
X_4595_ clknet_leaf_8_clock _0401_ VGND VGND VPWR VPWR fifo1.mem\[10\]\[6\] sky130_fd_sc_hd__dfxtp_1
X_3546_ _0712_ _1754_ _2103_ _2104_ net58 VGND VGND VPWR VPWR _0587_ sky130_fd_sc_hd__a32o_1
X_3477_ _2071_ VGND VGND VPWR VPWR _2072_ sky130_fd_sc_hd__clkbuf_2
X_2428_ fifo1.mem\[15\]\[5\] _1189_ VGND VGND VPWR VPWR _1313_ sky130_fd_sc_hd__and2b_1
X_2359_ _1220_ fifo1.mem\[9\]\[3\] _1245_ VGND VGND VPWR VPWR _1246_ sky130_fd_sc_hd__o21ai_1
X_4029_ _0939_ _0943_ _0953_ VGND VGND VPWR VPWR _0122_ sky130_fd_sc_hd__o21a_1
XFILLER_0_39_407 VGND VGND VPWR VPWR sky130_fd_sc_hd__fill_1
XFILLER_0_66_248 VGND VGND VPWR VPWR sky130_fd_sc_hd__decap_4
XFILLER_0_81_218 VGND VGND VPWR VPWR sky130_fd_sc_hd__decap_6
XFILLER_0_19_175 VGND VGND VPWR VPWR sky130_fd_sc_hd__decap_8
XFILLER_0_22_307 VGND VGND VPWR VPWR sky130_fd_sc_hd__fill_1
XFILLER_0_15_381 VGND VGND VPWR VPWR sky130_fd_sc_hd__fill_1
XFILLER_0_89_329 VGND VGND VPWR VPWR sky130_fd_sc_hd__decap_6
XFILLER_0_72_229 VGND VGND VPWR VPWR sky130_fd_sc_hd__decap_3
XFILLER_0_5_529 VPWR VGND VPWR VGND sky130_ef_sc_hd__decap_12
XFILLER_0_31_57 VGND VGND VPWR VPWR sky130_fd_sc_hd__decap_4
XFILLER_0_25_167 VGND VGND VPWR VPWR sky130_fd_sc_hd__fill_1
Xhold208 fifo1.mem\[2\]\[3\] VGND VGND VPWR VPWR net256 sky130_fd_sc_hd__dlygate4sd3_1
X_3400_ _1733_ _1042_ VGND VGND VPWR VPWR _2007_ sky130_fd_sc_hd__and2_1
X_4380_ clknet_leaf_8_clock _0194_ VGND VGND VPWR VPWR fifo1.mem\[5\]\[0\] sky130_fd_sc_hd__dfxtp_1
Xhold219 fifo2.mem\[15\]\[4\] VGND VGND VPWR VPWR net267 sky130_fd_sc_hd__dlygate4sd3_1
XFILLER_0_0_245 VGND VGND VPWR VPWR sky130_fd_sc_hd__fill_1
XFILLER_0_0_223 VGND VGND VPWR VPWR sky130_fd_sc_hd__fill_1
X_3331_ fifo3.mem\[7\]\[6\] _1942_ _1956_ VGND VGND VPWR VPWR _1957_ sky130_fd_sc_hd__o21ai_1
XFILLER_0_21_384 VGND VGND VPWR VPWR sky130_fd_sc_hd__decap_8
XTAP_502 VGND VPWR sky130_fd_sc_hd__tapvpwrvgnd_1
XTAP_513 VGND VPWR sky130_fd_sc_hd__tapvpwrvgnd_1
XTAP_524 VGND VPWR sky130_fd_sc_hd__tapvpwrvgnd_1
X_3262_ _1827_ _1883_ _0011_ _1890_ VGND VGND VPWR VPWR _1891_ sky130_fd_sc_hd__o211ai_4
XTAP_535 VGND VPWR sky130_fd_sc_hd__tapvpwrvgnd_1
XTAP_546 VGND VPWR sky130_fd_sc_hd__tapvpwrvgnd_1
XTAP_557 VGND VPWR sky130_fd_sc_hd__tapvpwrvgnd_1
X_3193_ fifo3.mem\[12\]\[1\] fifo3.mem\[13\]\[1\] fifo3.mem\[14\]\[1\] fifo3.mem\[15\]\[1\]
+ _1805_ _1807_ VGND VGND VPWR VPWR _1824_ sky130_fd_sc_hd__mux4_1
XTAP_568 VGND VPWR sky130_fd_sc_hd__tapvpwrvgnd_1
XTAP_579 VGND VPWR sky130_fd_sc_hd__tapvpwrvgnd_1
XFILLER_0_56_65 VGND VGND VPWR VPWR sky130_fd_sc_hd__fill_2
X_2213_ _0763_ _1121_ _1125_ _1132_ VGND VGND VPWR VPWR _0226_ sky130_fd_sc_hd__a31o_1
X_2144_ _0764_ _1096_ _1097_ net144 VGND VGND VPWR VPWR _0191_ sky130_fd_sc_hd__a22o_1
XFILLER_0_72_53 VGND VGND VPWR VPWR sky130_fd_sc_hd__fill_1
XFILLER_0_48_259 VGND VGND VPWR VPWR sky130_fd_sc_hd__decap_8
XFILLER_0_91_505 VPWR VGND VPWR VGND sky130_ef_sc_hd__decap_12
XFILLER_0_29_462 VPWR VGND VPWR VGND sky130_ef_sc_hd__decap_12
XFILLER_0_16_123 VGND VGND VPWR VPWR sky130_fd_sc_hd__decap_8
X_2977_ _1569_ fifo2.mem\[12\]\[5\] _1570_ VGND VGND VPWR VPWR _1680_ sky130_fd_sc_hd__o21bai_1
XFILLER_0_56_270 VPWR VGND VPWR VGND sky130_ef_sc_hd__decap_12
X_4716_ clknet_leaf_53_clock _0522_ VGND VGND VPWR VPWR fifo3.wr_pointer\[0\] sky130_fd_sc_hd__dfxtp_2
X_4647_ clknet_leaf_24_clock _0453_ VGND VGND VPWR VPWR fifo2.mem\[6\]\[6\] sky130_fd_sc_hd__dfxtp_1
XFILLER_0_12_362 VGND VGND VPWR VPWR sky130_fd_sc_hd__fill_2
X_4578_ clknet_leaf_49_clock _0384_ VGND VGND VPWR VPWR fifo3.mem\[15\]\[7\] sky130_fd_sc_hd__dfxtp_1
X_3529_ _1772_ _1420_ _1774_ _1775_ fifo3.mem\[11\]\[1\] VGND VGND VPWR VPWR _2096_
+ sky130_fd_sc_hd__o311ai_1
XFILLER_0_39_237 VGND VGND VPWR VPWR sky130_fd_sc_hd__decap_4
XFILLER_0_47_281 VGND VGND VPWR VPWR sky130_fd_sc_hd__decap_6
XFILLER_0_35_443 VGND VGND VPWR VPWR sky130_fd_sc_hd__decap_4
XFILLER_0_35_476 VGND VGND VPWR VPWR sky130_fd_sc_hd__fill_1
XFILLER_0_50_402 VPWR VGND VPWR VGND sky130_ef_sc_hd__decap_12
XFILLER_0_62_262 VGND VGND VPWR VPWR sky130_fd_sc_hd__decap_8
XFILLER_0_89_137 VGND VGND VPWR VPWR sky130_fd_sc_hd__decap_4
Xhold91 fifo2.mem\[8\]\[7\] VGND VGND VPWR VPWR net139 sky130_fd_sc_hd__dlygate4sd3_1
Xhold80 fifo2.mem\[13\]\[3\] VGND VGND VPWR VPWR net128 sky130_fd_sc_hd__dlygate4sd3_1
XFILLER_0_26_79 VGND VGND VPWR VPWR sky130_fd_sc_hd__decap_4
X_2900_ fifo2.mem\[13\]\[3\] _1567_ VGND VGND VPWR VPWR _1605_ sky130_fd_sc_hd__and2b_1
XFILLER_0_45_218 VGND VGND VPWR VPWR sky130_fd_sc_hd__decap_6
X_3880_ _0729_ VGND VGND VPWR VPWR _0856_ sky130_fd_sc_hd__clkbuf_4
XFILLER_0_26_421 VGND VGND VPWR VPWR sky130_fd_sc_hd__decap_6
X_2831_ _0007_ VGND VGND VPWR VPWR _1537_ sky130_fd_sc_hd__inv_2
XFILLER_0_5_337 VPWR VGND VPWR VGND sky130_ef_sc_hd__decap_12
X_2762_ _1102_ _1494_ VGND VGND VPWR VPWR _1495_ sky130_fd_sc_hd__nor2_4
X_4501_ clknet_leaf_39_clock _0307_ VGND VGND VPWR VPWR fifo2.mem\[10\]\[2\] sky130_fd_sc_hd__dfxtp_1
X_2693_ _1467_ _1438_ _0722_ fifo2.mem\[2\]\[6\] _0967_ VGND VGND VPWR VPWR _1474_
+ sky130_fd_sc_hd__o311a_1
X_4432_ clknet_leaf_50_clock _0013_ VGND VGND VPWR VPWR fsm1.rst_int_reg sky130_fd_sc_hd__dfxtp_1
X_4363_ clknet_leaf_51_clock _0177_ VGND VGND VPWR VPWR fifo2.mem\[15\]\[1\] sky130_fd_sc_hd__dfxtp_1
XTAP_332 VGND VPWR sky130_fd_sc_hd__tapvpwrvgnd_1
XTAP_321 VGND VPWR sky130_fd_sc_hd__tapvpwrvgnd_1
X_3314_ _1827_ _1934_ _0011_ _1940_ VGND VGND VPWR VPWR _1941_ sky130_fd_sc_hd__o211ai_4
XTAP_310 VGND VPWR sky130_fd_sc_hd__tapvpwrvgnd_1
X_4294_ clknet_leaf_62_clock _0108_ VGND VGND VPWR VPWR fifo3.mem\[5\]\[3\] sky130_fd_sc_hd__dfxtp_1
XFILLER_0_67_53 VGND VGND VPWR VPWR sky130_fd_sc_hd__decap_3
XFILLER_0_67_75 VPWR VGND VPWR VGND sky130_ef_sc_hd__decap_12
XTAP_365 VGND VPWR sky130_fd_sc_hd__tapvpwrvgnd_1
XTAP_354 VGND VPWR sky130_fd_sc_hd__tapvpwrvgnd_1
XTAP_343 VGND VPWR sky130_fd_sc_hd__tapvpwrvgnd_1
XTAP_376 VGND VPWR sky130_fd_sc_hd__tapvpwrvgnd_1
X_3245_ fifo3.mem\[3\]\[3\] VGND VGND VPWR VPWR _1874_ sky130_fd_sc_hd__inv_2
XTAP_387 VGND VPWR sky130_fd_sc_hd__tapvpwrvgnd_1
XTAP_398 VGND VPWR sky130_fd_sc_hd__tapvpwrvgnd_1
X_3176_ fifo3.mem\[4\]\[0\] fifo3.mem\[5\]\[0\] fifo3.mem\[6\]\[0\] fifo3.mem\[7\]\[0\]
+ _1805_ _1807_ VGND VGND VPWR VPWR _1808_ sky130_fd_sc_hd__mux4_1
XFILLER_0_83_85 VGND VGND VPWR VPWR sky130_fd_sc_hd__decap_4
XFILLER_0_13_3 VPWR VGND VPWR VGND sky130_ef_sc_hd__decap_12
X_2127_ fifo2.mem\[15\]\[3\] _1091_ _1093_ _0930_ VGND VGND VPWR VPWR _0179_ sky130_fd_sc_hd__a22o_1
XPHY_27 VGND VGND VPWR VPWR sky130_fd_sc_hd__decap_3
XPHY_16 VGND VGND VPWR VPWR sky130_fd_sc_hd__decap_3
XPHY_38 VGND VGND VPWR VPWR sky130_fd_sc_hd__decap_3
XFILLER_0_76_332 VGND VGND VPWR VPWR sky130_fd_sc_hd__fill_1
XPHY_49 VGND VGND VPWR VPWR sky130_fd_sc_hd__decap_3
XFILLER_0_91_335 VGND VGND VPWR VPWR sky130_fd_sc_hd__fill_1
XFILLER_0_29_281 VGND VGND VPWR VPWR sky130_fd_sc_hd__fill_2
XFILLER_0_17_443 VGND VGND VPWR VPWR sky130_fd_sc_hd__decap_4
XFILLER_0_27_207 VGND VGND VPWR VPWR sky130_fd_sc_hd__fill_2
XFILLER_0_55_516 VGND VGND VPWR VPWR sky130_fd_sc_hd__fill_2
XFILLER_0_27_229 VGND VGND VPWR VPWR sky130_fd_sc_hd__fill_1
XFILLER_0_55_538 VGND VGND VPWR VPWR sky130_fd_sc_hd__decap_3
XFILLER_0_67_387 VGND VGND VPWR VPWR sky130_fd_sc_hd__decap_4
XFILLER_0_82_357 VGND VGND VPWR VPWR sky130_fd_sc_hd__decap_6
XFILLER_0_23_413 VGND VGND VPWR VPWR sky130_fd_sc_hd__decap_8
XFILLER_0_35_295 VGND VGND VPWR VPWR sky130_fd_sc_hd__fill_1
XFILLER_0_10_107 VPWR VGND VPWR VGND sky130_ef_sc_hd__decap_12
XFILLER_0_37_78 VGND VGND VPWR VPWR sky130_fd_sc_hd__decap_8
X_3030_ fifo2.mem\[8\]\[7\] fifo2.mem\[9\]\[7\] fifo2.mem\[10\]\[7\] fifo2.mem\[11\]\[7\]
+ _1557_ _1540_ VGND VGND VPWR VPWR _1731_ sky130_fd_sc_hd__mux4_2
XFILLER_0_53_11 VGND VGND VPWR VPWR sky130_fd_sc_hd__fill_1
XFILLER_0_53_66 VGND VGND VPWR VPWR sky130_fd_sc_hd__fill_1
X_3932_ _0889_ syn.count1\[5\] VGND VGND VPWR VPWR _0891_ sky130_fd_sc_hd__and2_1
XFILLER_0_58_365 VGND VGND VPWR VPWR sky130_fd_sc_hd__decap_4
X_3863_ _0760_ _0825_ _0830_ _0845_ VGND VGND VPWR VPWR _0064_ sky130_fd_sc_hd__a31o_1
X_2814_ fifo1.mem\[0\]\[1\] fifo1.mem\[1\]\[1\] fifo1.mem\[2\]\[1\] fifo1.mem\[3\]\[1\]
+ _1317_ _1339_ VGND VGND VPWR VPWR _1527_ sky130_fd_sc_hd__mux4_1
XFILLER_0_26_240 VGND VGND VPWR VPWR sky130_fd_sc_hd__fill_2
XFILLER_0_26_251 VGND VGND VPWR VPWR sky130_fd_sc_hd__fill_1
X_3794_ _0785_ _0786_ fifo3.mem\[7\]\[4\] VGND VGND VPWR VPWR _0793_ sky130_fd_sc_hd__and3_1
X_2745_ _1108_ _1488_ _1489_ net155 VGND VGND VPWR VPWR _0401_ sky130_fd_sc_hd__a22o_1
X_2676_ _1107_ _1465_ _1466_ net315 VGND VGND VPWR VPWR _0355_ sky130_fd_sc_hd__a22o_1
XFILLER_0_41_243 VPWR VGND VPWR VGND sky130_ef_sc_hd__decap_12
XFILLER_0_41_287 VGND VGND VPWR VPWR sky130_fd_sc_hd__fill_1
X_4415_ clknet_leaf_5_clock _0229_ VGND VGND VPWR VPWR fifo1.mem\[7\]\[8\] sky130_fd_sc_hd__dfxtp_1
X_4346_ clknet_leaf_45_clock _0160_ VGND VGND VPWR VPWR regis.internal_parity\[1\]
+ sky130_fd_sc_hd__dfxtp_1
XFILLER_0_1_373 VPWR VGND VPWR VGND sky130_ef_sc_hd__decap_12
X_4277_ clknet_leaf_47_clock _0091_ VGND VGND VPWR VPWR syn.count2\[1\] sky130_fd_sc_hd__dfxtp_2
XTAP_184 VGND VPWR sky130_fd_sc_hd__tapvpwrvgnd_1
XTAP_195 VGND VPWR sky130_fd_sc_hd__tapvpwrvgnd_1
X_3228_ _1846_ fifo3.mem\[6\]\[2\] _1857_ VGND VGND VPWR VPWR _1858_ sky130_fd_sc_hd__o21ai_1
X_3159_ _0613_ _0749_ _1112_ VGND VGND VPWR VPWR _1800_ sky130_fd_sc_hd__and3_1
XFILLER_0_68_118 VPWR VGND VPWR VGND sky130_ef_sc_hd__decap_12
XFILLER_0_89_490 VPWR VGND VPWR VGND sky130_ef_sc_hd__decap_12
XFILLER_0_37_505 VGND VGND VPWR VPWR sky130_fd_sc_hd__decap_3
XFILLER_0_76_195 VGND VGND VPWR VPWR sky130_fd_sc_hd__fill_1
XFILLER_0_64_313 VGND VGND VPWR VPWR sky130_fd_sc_hd__fill_1
XFILLER_0_91_187 VGND VGND VPWR VPWR sky130_fd_sc_hd__decap_8
XFILLER_0_91_165 VGND VGND VPWR VPWR sky130_fd_sc_hd__decap_3
XFILLER_0_17_295 VGND VGND VPWR VPWR sky130_fd_sc_hd__fill_2
XFILLER_0_2_3 VPWR VGND VPWR VGND sky130_ef_sc_hd__decap_12
XFILLER_0_87_449 VGND VGND VPWR VPWR sky130_fd_sc_hd__decap_4
XFILLER_0_67_140 VGND VGND VPWR VPWR sky130_fd_sc_hd__decap_3
XFILLER_0_82_110 VGND VGND VPWR VPWR sky130_fd_sc_hd__decap_4
XFILLER_0_82_121 VGND VGND VPWR VPWR sky130_fd_sc_hd__decap_3
XFILLER_0_70_305 VGND VGND VPWR VPWR sky130_fd_sc_hd__decap_3
XFILLER_0_2_104 VGND VGND VPWR VPWR sky130_fd_sc_hd__decap_8
XFILLER_0_2_137 VGND VGND VPWR VPWR sky130_fd_sc_hd__decap_3
X_2530_ fifo3.rd_pointer\[1\] _0637_ _1404_ fifo3.rd_pointer\[2\] VGND VGND VPWR VPWR
+ _1409_ sky130_fd_sc_hd__a31o_1
X_2461_ fifo1.mem\[3\]\[6\] _1320_ _1344_ VGND VGND VPWR VPWR _1345_ sky130_fd_sc_hd__o21ai_1
X_4200_ regis.packet_parity\[3\] regis.internal_parity\[3\] VGND VGND VPWR VPWR _1072_
+ sky130_fd_sc_hd__or2_1
X_2392_ _1189_ fifo1.mem\[14\]\[4\] _1178_ VGND VGND VPWR VPWR _1278_ sky130_fd_sc_hd__o21ai_1
X_4131_ regis.header_byte\[0\] _1027_ _0661_ fsm1.detect_add VGND VGND VPWR VPWR _1028_
+ sky130_fd_sc_hd__a22o_1
X_4062_ _0732_ _0741_ _0857_ _0975_ net79 VGND VGND VPWR VPWR _0133_ sky130_fd_sc_hd__a32o_1
XFILLER_0_3_35 VGND VGND VPWR VPWR sky130_fd_sc_hd__fill_1
XFILLER_0_3_57 VPWR VGND VPWR VGND sky130_ef_sc_hd__decap_12
XFILLER_0_64_43 VGND VGND VPWR VPWR sky130_fd_sc_hd__fill_2
X_3013_ _1704_ _1701_ _1710_ _1714_ VGND VGND VPWR VPWR _1715_ sky130_fd_sc_hd__o2bb2ai_1
XFILLER_0_86_460 VPWR VGND VPWR VGND sky130_ef_sc_hd__decap_12
X_3915_ net11 net41 _0652_ VGND VGND VPWR VPWR _0879_ sky130_fd_sc_hd__nand3b_1
XFILLER_0_46_346 VGND VGND VPWR VPWR sky130_fd_sc_hd__fill_2
XFILLER_0_6_421 VGND VGND VPWR VPWR sky130_fd_sc_hd__fill_2
X_3846_ fifo3.wr_pointer\[0\] VGND VGND VPWR VPWR _0831_ sky130_fd_sc_hd__clkbuf_4
XFILLER_0_89_51 VGND VGND VPWR VPWR sky130_fd_sc_hd__decap_4
X_3777_ _0779_ net13 VGND VGND VPWR VPWR _0780_ sky130_fd_sc_hd__and2_2
X_2728_ _1098_ _1485_ _1486_ net240 VGND VGND VPWR VPWR _0387_ sky130_fd_sc_hd__a22o_1
X_2659_ _1110_ _1462_ _1463_ net53 VGND VGND VPWR VPWR _0341_ sky130_fd_sc_hd__a22o_1
X_4329_ clknet_leaf_39_clock _0143_ VGND VGND VPWR VPWR fifo1.data_in\[1\] sky130_fd_sc_hd__dfxtp_1
XFILLER_0_64_121 VGND VGND VPWR VPWR sky130_fd_sc_hd__fill_2
XFILLER_0_52_305 VGND VGND VPWR VPWR sky130_fd_sc_hd__decap_3
XFILLER_0_52_349 VGND VGND VPWR VPWR sky130_fd_sc_hd__fill_1
XFILLER_0_20_235 VGND VGND VPWR VPWR sky130_fd_sc_hd__decap_3
XTAP_909 VGND VPWR sky130_fd_sc_hd__tapvpwrvgnd_1
XFILLER_0_18_69 VGND VGND VPWR VPWR sky130_fd_sc_hd__decap_8
XFILLER_0_87_279 VGND VGND VPWR VPWR sky130_fd_sc_hd__fill_1
XFILLER_0_55_110 VGND VGND VPWR VPWR sky130_fd_sc_hd__fill_2
XFILLER_0_7_207 VGND VGND VPWR VPWR sky130_fd_sc_hd__fill_1
X_3700_ fsm1.ld_state fsm1.laf_state fsm1.present_state\[1\] _0720_ VGND VGND VPWR
+ VPWR _0721_ sky130_fd_sc_hd__o31a_2
XFILLER_0_83_485 VPWR VGND VPWR VGND sky130_ef_sc_hd__decap_12
X_4680_ clknet_leaf_62_clock _0486_ VGND VGND VPWR VPWR fifo3.mem\[4\]\[3\] sky130_fd_sc_hd__dfxtp_1
XFILLER_0_43_305 VGND VGND VPWR VPWR sky130_fd_sc_hd__decap_8
X_3631_ _0659_ _0660_ _0658_ VGND VGND VPWR VPWR _0667_ sky130_fd_sc_hd__nand3b_1
XFILLER_0_70_135 VGND VGND VPWR VPWR sky130_fd_sc_hd__decap_4
X_3562_ _0739_ _1753_ _0920_ _2106_ net66 VGND VGND VPWR VPWR _0601_ sky130_fd_sc_hd__a32o_1
X_2513_ fifo1.count\[5\] _1394_ _1173_ fifo1.count\[6\] VGND VGND VPWR VPWR _1395_
+ sky130_fd_sc_hd__o31a_1
X_3493_ _2072_ _0783_ net246 _2080_ VGND VGND VPWR VPWR _0558_ sky130_fd_sc_hd__a31o_1
XFILLER_0_51_393 VGND VGND VPWR VPWR sky130_fd_sc_hd__fill_1
X_2444_ fifo1.count\[4\] fifo1.count\[3\] _1286_ VGND VGND VPWR VPWR _1328_ sky130_fd_sc_hd__nor3_1
X_2375_ fifo1.mem\[7\]\[4\] _1221_ VGND VGND VPWR VPWR _1261_ sky130_fd_sc_hd__and2b_1
X_4114_ regis.fifo_full_state\[5\] _0990_ _0690_ VGND VGND VPWR VPWR _1014_ sky130_fd_sc_hd__o21ba_1
X_4045_ _0761_ _0960_ _0956_ _0965_ VGND VGND VPWR VPWR _0126_ sky130_fd_sc_hd__a31o_1
XFILLER_0_91_41 VPWR VGND VPWR VGND sky130_ef_sc_hd__decap_12
XFILLER_0_78_224 VGND VGND VPWR VPWR sky130_fd_sc_hd__decap_8
XFILLER_0_91_85 VPWR VGND VPWR VGND sky130_ef_sc_hd__decap_12
XFILLER_0_91_63 VPWR VGND VPWR VGND sky130_ef_sc_hd__decap_12
XFILLER_0_19_335 VGND VGND VPWR VPWR sky130_fd_sc_hd__fill_1
X_3829_ _0779_ fifo3.mem\[8\]\[6\] _0800_ VGND VGND VPWR VPWR _0817_ sky130_fd_sc_hd__and3_1
XFILLER_0_6_251 VGND VGND VPWR VPWR sky130_fd_sc_hd__fill_1
XFILLER_0_61_113 VGND VGND VPWR VPWR sky130_fd_sc_hd__fill_2
XFILLER_0_61_146 VGND VGND VPWR VPWR sky130_fd_sc_hd__decap_8
XFILLER_0_42_360 VGND VGND VPWR VPWR sky130_fd_sc_hd__decap_4
XFILLER_0_30_533 VGND VGND VPWR VPWR sky130_fd_sc_hd__decap_8
XFILLER_0_57_408 VGND VGND VPWR VPWR sky130_fd_sc_hd__fill_2
XFILLER_0_37_121 VGND VGND VPWR VPWR sky130_fd_sc_hd__fill_1
XFILLER_0_65_474 VGND VGND VPWR VPWR sky130_fd_sc_hd__fill_1
XFILLER_0_20_15 VPWR VGND VPWR VGND sky130_ef_sc_hd__decap_12
XFILLER_0_52_113 VGND VGND VPWR VPWR sky130_fd_sc_hd__decap_3
XFILLER_0_65_496 VGND VGND VPWR VPWR sky130_fd_sc_hd__fill_1
XFILLER_0_80_477 VGND VGND VPWR VPWR sky130_fd_sc_hd__decap_8
XFILLER_0_33_382 VGND VGND VPWR VPWR sky130_fd_sc_hd__decap_8
XFILLER_0_0_405 VGND VGND VPWR VPWR sky130_fd_sc_hd__decap_4
XFILLER_0_33_393 VGND VGND VPWR VPWR sky130_fd_sc_hd__decap_8
XFILLER_0_0_449 VGND VGND VPWR VPWR sky130_fd_sc_hd__decap_8
XTAP_706 VGND VPWR sky130_fd_sc_hd__tapvpwrvgnd_1
XTAP_717 VGND VPWR sky130_fd_sc_hd__tapvpwrvgnd_1
XTAP_728 VGND VPWR sky130_fd_sc_hd__tapvpwrvgnd_1
XTAP_739 VGND VPWR sky130_fd_sc_hd__tapvpwrvgnd_1
X_2160_ _0739_ VGND VGND VPWR VPWR _1107_ sky130_fd_sc_hd__clkbuf_4
XFILLER_0_88_533 VGND VGND VPWR VPWR sky130_fd_sc_hd__decap_8
XFILLER_0_61_33 VPWR VGND VPWR VGND sky130_ef_sc_hd__decap_12
X_2993_ _1664_ _1695_ _0974_ VGND VGND VPWR VPWR _0443_ sky130_fd_sc_hd__a21oi_1
XFILLER_0_0_69 VPWR VGND VPWR VGND sky130_ef_sc_hd__decap_12
XFILLER_0_28_165 VGND VGND VPWR VPWR sky130_fd_sc_hd__fill_2
X_4732_ clknet_leaf_32_clock _0538_ VGND VGND VPWR VPWR net29 sky130_fd_sc_hd__dfxtp_1
X_4663_ clknet_leaf_2_clock _0469_ VGND VGND VPWR VPWR fifo3.mem\[2\]\[4\] sky130_fd_sc_hd__dfxtp_1
XFILLER_0_43_113 VPWR VGND VPWR VGND sky130_ef_sc_hd__decap_12
X_3614_ net13 VGND VGND VPWR VPWR _0652_ sky130_fd_sc_hd__clkbuf_8
X_4594_ clknet_leaf_10_clock _0400_ VGND VGND VPWR VPWR fifo1.mem\[10\]\[5\] sky130_fd_sc_hd__dfxtp_1
XFILLER_0_12_533 VGND VGND VPWR VPWR sky130_fd_sc_hd__decap_8
X_3545_ _0803_ _2103_ _0921_ VGND VGND VPWR VPWR _2104_ sky130_fd_sc_hd__a21oi_4
X_3476_ _0826_ _0769_ _0834_ _2070_ VGND VGND VPWR VPWR _2071_ sky130_fd_sc_hd__or4b_1
XFILLER_0_86_41 VGND VGND VPWR VPWR sky130_fd_sc_hd__fill_2
X_2427_ _1296_ fifo1.mem\[14\]\[5\] _1183_ VGND VGND VPWR VPWR _1312_ sky130_fd_sc_hd__o21ai_1
XFILLER_0_43_3 VPWR VGND VPWR VGND sky130_ef_sc_hd__decap_12
X_2358_ _1221_ fifo1.mem\[8\]\[3\] _1177_ VGND VGND VPWR VPWR _1245_ sky130_fd_sc_hd__o21ba_1
X_2289_ _0001_ VGND VGND VPWR VPWR _1177_ sky130_fd_sc_hd__clkbuf_4
X_4028_ fifo3.mem\[6\]\[8\] _0944_ _0942_ VGND VGND VPWR VPWR _0953_ sky130_fd_sc_hd__a21bo_1
XFILLER_0_19_121 VGND VGND VPWR VPWR sky130_fd_sc_hd__fill_1
XFILLER_0_34_113 VGND VGND VPWR VPWR sky130_fd_sc_hd__decap_4
XFILLER_0_62_444 VGND VGND VPWR VPWR sky130_fd_sc_hd__fill_1
XFILLER_0_30_352 VPWR VGND VPWR VGND sky130_ef_sc_hd__decap_12
XFILLER_0_85_503 VGND VGND VPWR VPWR sky130_fd_sc_hd__fill_1
XFILLER_0_72_208 VGND VGND VPWR VPWR sky130_fd_sc_hd__fill_2
XFILLER_0_31_25 VPWR VGND VPWR VGND sky130_ef_sc_hd__decap_12
XFILLER_0_25_113 VGND VGND VPWR VPWR sky130_fd_sc_hd__decap_8
XFILLER_0_53_455 VGND VGND VPWR VPWR sky130_fd_sc_hd__fill_1
Xhold209 fifo1.mem\[6\]\[6\] VGND VGND VPWR VPWR net257 sky130_fd_sc_hd__dlygate4sd3_1
XFILLER_0_21_352 VGND VGND VPWR VPWR sky130_fd_sc_hd__decap_3
X_3330_ _1846_ fifo3.mem\[6\]\[6\] _1857_ VGND VGND VPWR VPWR _1956_ sky130_fd_sc_hd__o21a_1
XTAP_503 VGND VPWR sky130_fd_sc_hd__tapvpwrvgnd_1
XTAP_514 VGND VPWR sky130_fd_sc_hd__tapvpwrvgnd_1
XTAP_525 VGND VPWR sky130_fd_sc_hd__tapvpwrvgnd_1
X_3261_ _1886_ _1889_ _0010_ VGND VGND VPWR VPWR _1890_ sky130_fd_sc_hd__o21ai_2
XTAP_536 VGND VPWR sky130_fd_sc_hd__tapvpwrvgnd_1
XTAP_547 VGND VPWR sky130_fd_sc_hd__tapvpwrvgnd_1
XTAP_558 VGND VPWR sky130_fd_sc_hd__tapvpwrvgnd_1
XFILLER_0_56_22 VGND VGND VPWR VPWR sky130_fd_sc_hd__decap_6
X_3192_ _1812_ _1822_ _1814_ VGND VGND VPWR VPWR _1823_ sky130_fd_sc_hd__a21o_1
XTAP_569 VGND VPWR sky130_fd_sc_hd__tapvpwrvgnd_1
X_2212_ _1126_ _1120_ fifo1.mem\[7\]\[5\] VGND VGND VPWR VPWR _1132_ sky130_fd_sc_hd__and3_1
X_2143_ _0763_ _1096_ _1097_ net303 VGND VGND VPWR VPWR _0190_ sky130_fd_sc_hd__a22o_1
XFILLER_0_88_363 VGND VGND VPWR VPWR sky130_fd_sc_hd__fill_1
XFILLER_0_8_302 VGND VGND VPWR VPWR sky130_fd_sc_hd__decap_6
XFILLER_0_48_249 VGND VGND VPWR VPWR sky130_fd_sc_hd__decap_3
XFILLER_0_91_517 VPWR VGND VPWR VGND sky130_ef_sc_hd__decap_12
XFILLER_0_8_313 VGND VGND VPWR VPWR sky130_fd_sc_hd__fill_1
XFILLER_0_29_474 VPWR VGND VPWR VGND sky130_ef_sc_hd__decap_12
XFILLER_0_8_357 VGND VGND VPWR VPWR sky130_fd_sc_hd__fill_2
X_2976_ fifo2.mem\[13\]\[5\] _1539_ VGND VGND VPWR VPWR _1679_ sky130_fd_sc_hd__and2b_1
XFILLER_0_56_282 VGND VGND VPWR VPWR sky130_fd_sc_hd__decap_4
X_4715_ clknet_leaf_41_clock _0521_ VGND VGND VPWR VPWR net38 sky130_fd_sc_hd__dfxtp_1
XFILLER_0_44_477 VPWR VGND VPWR VGND sky130_ef_sc_hd__decap_12
X_4646_ clknet_leaf_21_clock _0452_ VGND VGND VPWR VPWR fifo2.mem\[6\]\[5\] sky130_fd_sc_hd__dfxtp_1
X_4577_ clknet_leaf_49_clock _0383_ VGND VGND VPWR VPWR fifo3.mem\[15\]\[6\] sky130_fd_sc_hd__dfxtp_1
XFILLER_0_12_341 VGND VGND VPWR VPWR sky130_fd_sc_hd__decap_6
X_3528_ _0925_ _2094_ _2095_ VGND VGND VPWR VPWR _0578_ sky130_fd_sc_hd__a21bo_1
X_3459_ _2030_ _2058_ _2059_ _1976_ VGND VGND VPWR VPWR _2060_ sky130_fd_sc_hd__nand4_1
XFILLER_0_39_249 VGND VGND VPWR VPWR sky130_fd_sc_hd__decap_4
XFILLER_0_35_455 VGND VGND VPWR VPWR sky130_fd_sc_hd__fill_1
XFILLER_0_7_390 VGND VGND VPWR VPWR sky130_fd_sc_hd__fill_2
XFILLER_0_50_414 VGND VGND VPWR VPWR sky130_fd_sc_hd__decap_6
XFILLER_0_22_149 VGND VGND VPWR VPWR sky130_fd_sc_hd__decap_8
XFILLER_0_62_296 VGND VGND VPWR VPWR sky130_fd_sc_hd__fill_1
XFILLER_0_89_105 VGND VGND VPWR VPWR sky130_fd_sc_hd__decap_6
Xclkbuf_leaf_54_clock clknet_3_1__leaf_clock VGND VGND VPWR VPWR clknet_leaf_54_clock
+ sky130_fd_sc_hd__clkbuf_16
Xhold92 fifo1.mem\[1\]\[8\] VGND VGND VPWR VPWR net140 sky130_fd_sc_hd__dlygate4sd3_1
Xhold70 fifo1.mem\[2\]\[1\] VGND VGND VPWR VPWR net118 sky130_fd_sc_hd__dlygate4sd3_1
Xhold81 fifo3.mem\[11\]\[7\] VGND VGND VPWR VPWR net129 sky130_fd_sc_hd__dlygate4sd3_1
XFILLER_0_26_47 VGND VGND VPWR VPWR sky130_fd_sc_hd__decap_6
X_2830_ _1536_ VGND VGND VPWR VPWR _0439_ sky130_fd_sc_hd__clkbuf_1
XFILLER_0_73_539 VGND VGND VPWR VPWR sky130_fd_sc_hd__fill_2
XFILLER_0_26_400 VGND VGND VPWR VPWR sky130_fd_sc_hd__decap_4
XFILLER_0_26_411 VGND VGND VPWR VPWR sky130_fd_sc_hd__decap_8
X_2761_ _1493_ VGND VGND VPWR VPWR _1494_ sky130_fd_sc_hd__clkbuf_4
XFILLER_0_5_349 VPWR VGND VPWR VGND sky130_ef_sc_hd__decap_12
X_4500_ clknet_leaf_40_clock _0306_ VGND VGND VPWR VPWR fifo2.mem\[10\]\[1\] sky130_fd_sc_hd__dfxtp_1
X_2692_ _0763_ _0724_ _1436_ _1473_ VGND VGND VPWR VPWR _0364_ sky130_fd_sc_hd__a31o_1
X_4431_ clknet_leaf_46_clock _0019_ VGND VGND VPWR VPWR fsm1.ld_state sky130_fd_sc_hd__dfxtp_4
XANTENNA_1 _0433_ VGND VGND VPWR VPWR sky130_fd_sc_hd__diode_2
X_4362_ clknet_leaf_51_clock _0176_ VGND VGND VPWR VPWR fifo2.mem\[15\]\[0\] sky130_fd_sc_hd__dfxtp_1
XTAP_333 VGND VPWR sky130_fd_sc_hd__tapvpwrvgnd_1
XTAP_322 VGND VPWR sky130_fd_sc_hd__tapvpwrvgnd_1
XTAP_311 VGND VPWR sky130_fd_sc_hd__tapvpwrvgnd_1
X_3313_ _1939_ _0010_ VGND VGND VPWR VPWR _1940_ sky130_fd_sc_hd__nand2_1
XTAP_300 VGND VPWR sky130_fd_sc_hd__tapvpwrvgnd_1
X_4293_ clknet_leaf_62_clock _0107_ VGND VGND VPWR VPWR fifo3.mem\[5\]\[2\] sky130_fd_sc_hd__dfxtp_1
XTAP_366 VGND VPWR sky130_fd_sc_hd__tapvpwrvgnd_1
XTAP_355 VGND VPWR sky130_fd_sc_hd__tapvpwrvgnd_1
XTAP_344 VGND VPWR sky130_fd_sc_hd__tapvpwrvgnd_1
X_3244_ _1871_ _1864_ _1872_ VGND VGND VPWR VPWR _1873_ sky130_fd_sc_hd__a21oi_1
XFILLER_0_67_87 VPWR VGND VPWR VGND sky130_ef_sc_hd__decap_12
XTAP_377 VGND VPWR sky130_fd_sc_hd__tapvpwrvgnd_1
XTAP_388 VGND VPWR sky130_fd_sc_hd__tapvpwrvgnd_1
XTAP_399 VGND VPWR sky130_fd_sc_hd__tapvpwrvgnd_1
XFILLER_0_83_42 VGND VGND VPWR VPWR sky130_fd_sc_hd__decap_6
X_3175_ _1806_ VGND VGND VPWR VPWR _1807_ sky130_fd_sc_hd__buf_4
X_2126_ net319 _1091_ _1093_ _0927_ VGND VGND VPWR VPWR _0178_ sky130_fd_sc_hd__a22o_1
XPHY_28 VGND VGND VPWR VPWR sky130_fd_sc_hd__decap_3
XPHY_17 VGND VGND VPWR VPWR sky130_fd_sc_hd__decap_3
XFILLER_0_16_91 VGND VGND VPWR VPWR sky130_fd_sc_hd__fill_1
XPHY_39 VGND VGND VPWR VPWR sky130_fd_sc_hd__decap_3
XFILLER_0_29_260 VPWR VGND VPWR VGND sky130_ef_sc_hd__decap_12
X_2959_ _1508_ _1620_ fifo2.count\[3\] VGND VGND VPWR VPWR _1662_ sky130_fd_sc_hd__o21ai_1
XFILLER_0_17_455 VGND VGND VPWR VPWR sky130_fd_sc_hd__fill_1
XFILLER_0_32_469 VGND VGND VPWR VPWR sky130_fd_sc_hd__decap_6
X_4629_ clknet_leaf_9_clock _0435_ VGND VGND VPWR VPWR net18 sky130_fd_sc_hd__dfxtp_1
XFILLER_0_12_182 VGND VGND VPWR VPWR sky130_fd_sc_hd__fill_2
XFILLER_0_27_219 VGND VGND VPWR VPWR sky130_fd_sc_hd__decap_4
XFILLER_0_23_469 VGND VGND VPWR VPWR sky130_fd_sc_hd__fill_1
XFILLER_0_10_119 VGND VGND VPWR VPWR sky130_fd_sc_hd__fill_2
XFILLER_0_31_491 VGND VGND VPWR VPWR sky130_fd_sc_hd__fill_2
X_3931_ _0890_ VGND VGND VPWR VPWR _0087_ sky130_fd_sc_hd__clkbuf_1
XFILLER_0_58_377 VGND VGND VPWR VPWR sky130_fd_sc_hd__decap_4
XFILLER_0_73_303 VGND VGND VPWR VPWR sky130_fd_sc_hd__fill_2
X_3862_ _0832_ _0840_ _0841_ _0844_ fifo3.mem\[1\]\[2\] VGND VGND VPWR VPWR _0845_
+ sky130_fd_sc_hd__o311a_1
X_2813_ _1525_ _1200_ VGND VGND VPWR VPWR _1526_ sky130_fd_sc_hd__and2_1
X_3793_ _0761_ _0778_ _0790_ _0792_ VGND VGND VPWR VPWR _0047_ sky130_fd_sc_hd__a31o_1
XFILLER_0_14_436 VGND VGND VPWR VPWR sky130_fd_sc_hd__decap_3
X_2744_ _1107_ _1488_ _1489_ net264 VGND VGND VPWR VPWR _0400_ sky130_fd_sc_hd__a22o_1
XFILLER_0_41_255 VGND VGND VPWR VPWR sky130_fd_sc_hd__fill_1
X_2675_ _1106_ _1465_ _1466_ net76 VGND VGND VPWR VPWR _0354_ sky130_fd_sc_hd__a22o_1
XFILLER_0_41_299 VGND VGND VPWR VPWR sky130_fd_sc_hd__fill_1
X_4414_ clknet_leaf_6_clock _0228_ VGND VGND VPWR VPWR fifo1.mem\[7\]\[7\] sky130_fd_sc_hd__dfxtp_1
X_4345_ clknet_leaf_45_clock _0159_ VGND VGND VPWR VPWR regis.internal_parity\[0\]
+ sky130_fd_sc_hd__dfxtp_1
XFILLER_0_1_385 VGND VGND VPWR VPWR sky130_fd_sc_hd__decap_6
X_4276_ clknet_leaf_47_clock _0090_ VGND VGND VPWR VPWR syn.count2\[0\] sky130_fd_sc_hd__dfxtp_2
XTAP_185 VGND VPWR sky130_fd_sc_hd__tapvpwrvgnd_1
XTAP_196 VGND VPWR sky130_fd_sc_hd__tapvpwrvgnd_1
X_3227_ _0009_ VGND VGND VPWR VPWR _1857_ sky130_fd_sc_hd__clkbuf_4
X_3158_ _0745_ _1152_ _1153_ net189 VGND VGND VPWR VPWR _0504_ sky130_fd_sc_hd__a22o_1
X_2109_ regis.internal_parity\[6\] regis.packet_parity\[6\] VGND VGND VPWR VPWR _1080_
+ sky130_fd_sc_hd__or2b_1
X_3089_ _0762_ _0838_ _1758_ _1765_ VGND VGND VPWR VPWR _0469_ sky130_fd_sc_hd__a31o_1
XFILLER_0_9_441 VGND VGND VPWR VPWR sky130_fd_sc_hd__decap_6
XFILLER_0_37_528 VPWR VGND VPWR VGND sky130_ef_sc_hd__decap_12
XFILLER_0_32_211 VGND VGND VPWR VPWR sky130_fd_sc_hd__fill_1
XFILLER_0_32_277 VGND VGND VPWR VPWR sky130_fd_sc_hd__fill_1
XFILLER_0_23_15 VPWR VGND VPWR VGND sky130_ef_sc_hd__decap_12
XFILLER_0_82_100 VGND VGND VPWR VPWR sky130_fd_sc_hd__fill_2
XFILLER_0_70_328 VGND VGND VPWR VPWR sky130_fd_sc_hd__decap_8
XFILLER_0_23_211 VGND VGND VPWR VPWR sky130_fd_sc_hd__decap_8
XFILLER_0_63_391 VGND VGND VPWR VPWR sky130_fd_sc_hd__fill_1
X_2460_ _1295_ fifo1.mem\[2\]\[6\] _1183_ VGND VGND VPWR VPWR _1344_ sky130_fd_sc_hd__o21a_1
X_4130_ _1026_ _0660_ fsm1.detect_add VGND VGND VPWR VPWR _1027_ sky130_fd_sc_hd__nand3_4
XFILLER_0_48_67 VGND VGND VPWR VPWR sky130_fd_sc_hd__fill_1
X_2391_ fifo1.mem\[13\]\[4\] _1221_ VGND VGND VPWR VPWR _1277_ sky130_fd_sc_hd__and2b_1
X_4061_ _0713_ _0741_ _0857_ _0975_ net193 VGND VGND VPWR VPWR _0132_ sky130_fd_sc_hd__a32o_1
X_3012_ _1705_ _1623_ _1625_ VGND VGND VPWR VPWR _1714_ sky130_fd_sc_hd__a21o_1
XFILLER_0_3_69 VPWR VGND VPWR VGND sky130_ef_sc_hd__decap_12
XFILLER_0_86_472 VGND VGND VPWR VPWR sky130_fd_sc_hd__decap_4
X_3914_ fifo1.soft_reset _0878_ _0701_ VGND VGND VPWR VPWR _0082_ sky130_fd_sc_hd__o21a_1
XFILLER_0_46_303 VGND VGND VPWR VPWR sky130_fd_sc_hd__decap_4
XFILLER_0_73_166 VGND VGND VPWR VPWR sky130_fd_sc_hd__fill_2
X_3845_ net46 VGND VGND VPWR VPWR _0830_ sky130_fd_sc_hd__clkbuf_4
XFILLER_0_61_317 VGND VGND VPWR VPWR sky130_fd_sc_hd__decap_4
X_3776_ fifo3.soft_reset VGND VGND VPWR VPWR _0779_ sky130_fd_sc_hd__inv_2
XFILLER_0_6_477 VGND VGND VPWR VPWR sky130_fd_sc_hd__decap_6
XFILLER_0_14_233 VGND VGND VPWR VPWR sky130_fd_sc_hd__fill_2
X_2727_ _1110_ _1485_ _1486_ net252 VGND VGND VPWR VPWR _0386_ sky130_fd_sc_hd__a22o_1
XFILLER_0_73_3 VPWR VGND VPWR VGND sky130_ef_sc_hd__decap_12
X_2658_ _1102_ _1462_ VGND VGND VPWR VPWR _1463_ sky130_fd_sc_hd__nor2_4
XFILLER_0_1_193 VPWR VGND VPWR VGND sky130_ef_sc_hd__decap_12
X_2589_ _0738_ _0869_ _1428_ _1434_ net186 VGND VGND VPWR VPWR _0300_ sky130_fd_sc_hd__a32o_1
X_4328_ clknet_leaf_39_clock _0142_ VGND VGND VPWR VPWR fifo1.data_in\[0\] sky130_fd_sc_hd__dfxtp_1
X_4259_ clknet_leaf_40_clock _0073_ VGND VGND VPWR VPWR fifo2.mem\[8\]\[2\] sky130_fd_sc_hd__dfxtp_1
XFILLER_0_49_163 VGND VGND VPWR VPWR sky130_fd_sc_hd__decap_4
XFILLER_0_9_260 VGND VGND VPWR VPWR sky130_fd_sc_hd__decap_8
XFILLER_0_64_133 VGND VGND VPWR VPWR sky130_fd_sc_hd__decap_6
XFILLER_0_52_317 VGND VGND VPWR VPWR sky130_fd_sc_hd__fill_1
XFILLER_0_20_214 VGND VGND VPWR VPWR sky130_fd_sc_hd__decap_4
XFILLER_0_18_15 VPWR VGND VPWR VGND sky130_ef_sc_hd__decap_12
XFILLER_0_87_225 VPWR VGND VPWR VGND sky130_ef_sc_hd__decap_12
XFILLER_0_83_431 VPWR VGND VPWR VGND sky130_ef_sc_hd__decap_12
XFILLER_0_68_494 VPWR VGND VPWR VGND sky130_ef_sc_hd__decap_12
XFILLER_0_55_166 VGND VGND VPWR VPWR sky130_fd_sc_hd__fill_2
XFILLER_0_83_497 VGND VGND VPWR VPWR sky130_fd_sc_hd__decap_6
XFILLER_0_24_531 VGND VGND VPWR VPWR sky130_fd_sc_hd__fill_1
X_3630_ _0633_ _0640_ _0645_ VGND VGND VPWR VPWR net42 sky130_fd_sc_hd__nand3_4
XFILLER_0_55_188 VGND VGND VPWR VPWR sky130_fd_sc_hd__decap_4
X_3561_ _0737_ _1753_ _0920_ _2106_ net64 VGND VGND VPWR VPWR _0600_ sky130_fd_sc_hd__a32o_1
XFILLER_0_70_147 VGND VGND VPWR VPWR sky130_fd_sc_hd__decap_8
X_2512_ fifo1.count\[4\] fifo1.count\[3\] _1286_ VGND VGND VPWR VPWR _1394_ sky130_fd_sc_hd__or3_1
XFILLER_0_3_447 VGND VGND VPWR VPWR sky130_fd_sc_hd__fill_1
XFILLER_0_11_236 VGND VGND VPWR VPWR sky130_fd_sc_hd__decap_4
X_3492_ _0765_ _2070_ net45 VGND VGND VPWR VPWR _2080_ sky130_fd_sc_hd__and3_1
X_2443_ _1293_ _1327_ _0757_ VGND VGND VPWR VPWR _0261_ sky130_fd_sc_hd__a21oi_1
X_2374_ _1176_ fifo1.mem\[6\]\[4\] _1233_ VGND VGND VPWR VPWR _1260_ sky130_fd_sc_hd__o21ai_1
X_4113_ _1011_ _1013_ _1005_ VGND VGND VPWR VPWR _0146_ sky130_fd_sc_hd__a21boi_1
XFILLER_0_75_65 VGND VGND VPWR VPWR sky130_fd_sc_hd__fill_2
X_4044_ _0957_ _0961_ _0962_ fifo2.mem\[1\]\[3\] _0963_ VGND VGND VPWR VPWR _0965_
+ sky130_fd_sc_hd__o311a_1
XFILLER_0_91_75 VGND VGND VPWR VPWR sky130_fd_sc_hd__decap_8
XFILLER_0_91_53 VGND VGND VPWR VPWR sky130_fd_sc_hd__decap_3
XFILLER_0_91_97 VGND VGND VPWR VPWR sky130_fd_sc_hd__decap_8
XFILLER_0_74_453 VPWR VGND VPWR VGND sky130_ef_sc_hd__decap_12
X_3828_ _0816_ VGND VGND VPWR VPWR _0058_ sky130_fd_sc_hd__clkbuf_1
XFILLER_0_34_328 VPWR VGND VPWR VGND sky130_ef_sc_hd__decap_12
X_3759_ _0764_ _0755_ _0758_ net225 VGND VGND VPWR VPWR _0041_ sky130_fd_sc_hd__a22o_1
XFILLER_0_69_225 VPWR VGND VPWR VGND sky130_ef_sc_hd__decap_12
XFILLER_0_37_100 VPWR VGND VPWR VGND sky130_ef_sc_hd__decap_12
XFILLER_0_25_306 VGND VGND VPWR VPWR sky130_fd_sc_hd__decap_8
XFILLER_0_37_177 VGND VGND VPWR VPWR sky130_fd_sc_hd__fill_1
XFILLER_0_20_27 VGND VGND VPWR VPWR sky130_fd_sc_hd__fill_1
XFILLER_0_21_501 VGND VGND VPWR VPWR sky130_fd_sc_hd__decap_3
XTAP_707 VGND VPWR sky130_fd_sc_hd__tapvpwrvgnd_1
XFILLER_0_29_69 VGND VGND VPWR VPWR sky130_fd_sc_hd__fill_1
XTAP_718 VGND VPWR sky130_fd_sc_hd__tapvpwrvgnd_1
XTAP_729 VGND VPWR sky130_fd_sc_hd__tapvpwrvgnd_1
XFILLER_0_88_501 VPWR VGND VPWR VGND sky130_ef_sc_hd__decap_12
XFILLER_0_45_57 VGND VGND VPWR VPWR sky130_fd_sc_hd__decap_6
XFILLER_0_0_37 VGND VGND VPWR VPWR sky130_fd_sc_hd__fill_1
XFILLER_0_56_431 VGND VGND VPWR VPWR sky130_fd_sc_hd__decap_4
XFILLER_0_61_45 VGND VGND VPWR VPWR sky130_fd_sc_hd__fill_1
X_2992_ _1554_ _1693_ _1694_ VGND VGND VPWR VPWR _1695_ sky130_fd_sc_hd__nand3_1
XFILLER_0_90_209 VPWR VGND VPWR VGND sky130_ef_sc_hd__decap_12
X_4731_ clknet_leaf_61_clock _0537_ VGND VGND VPWR VPWR net28 sky130_fd_sc_hd__dfxtp_1
XFILLER_0_56_475 VGND VGND VPWR VPWR sky130_fd_sc_hd__fill_1
XFILLER_0_16_317 VGND VGND VPWR VPWR sky130_fd_sc_hd__decap_3
X_4662_ clknet_leaf_2_clock _0468_ VGND VGND VPWR VPWR fifo3.mem\[2\]\[3\] sky130_fd_sc_hd__dfxtp_1
XFILLER_0_43_125 VGND VGND VPWR VPWR sky130_fd_sc_hd__decap_8
XFILLER_0_9_57 VPWR VGND VPWR VGND sky130_ef_sc_hd__decap_12
X_3613_ net2 net1 fifo1.soft_reset VGND VGND VPWR VPWR _0651_ sky130_fd_sc_hd__or3b_1
X_4593_ clknet_leaf_10_clock _0399_ VGND VGND VPWR VPWR fifo1.mem\[10\]\[4\] sky130_fd_sc_hd__dfxtp_1
X_3544_ _2102_ VGND VGND VPWR VPWR _2103_ sky130_fd_sc_hd__clkbuf_4
X_3475_ _0802_ VGND VGND VPWR VPWR _2070_ sky130_fd_sc_hd__buf_2
X_2426_ fifo1.mem\[13\]\[5\] _1189_ VGND VGND VPWR VPWR _1311_ sky130_fd_sc_hd__or2b_1
XFILLER_0_36_3 VPWR VGND VPWR VGND sky130_ef_sc_hd__decap_12
X_2357_ _1241_ _1243_ _0002_ VGND VGND VPWR VPWR _1244_ sky130_fd_sc_hd__a21o_1
X_2288_ _0000_ VGND VGND VPWR VPWR _1176_ sky130_fd_sc_hd__buf_4
X_4027_ _0938_ _0943_ _0952_ VGND VGND VPWR VPWR _0121_ sky130_fd_sc_hd__o21a_1
XFILLER_0_19_166 VGND VGND VPWR VPWR sky130_fd_sc_hd__fill_2
XFILLER_0_34_103 VGND VGND VPWR VPWR sky130_fd_sc_hd__decap_6
XFILLER_0_22_309 VGND VGND VPWR VPWR sky130_fd_sc_hd__decap_8
XFILLER_0_31_37 VGND VGND VPWR VPWR sky130_fd_sc_hd__decap_8
XFILLER_0_38_475 VGND VGND VPWR VPWR sky130_fd_sc_hd__fill_1
XFILLER_0_80_253 VGND VGND VPWR VPWR sky130_fd_sc_hd__fill_1
XFILLER_0_25_169 VGND VGND VPWR VPWR sky130_fd_sc_hd__decap_6
XFILLER_0_0_203 VPWR VGND VPWR VGND sky130_ef_sc_hd__decap_12
XFILLER_0_33_180 VPWR VGND VPWR VGND sky130_ef_sc_hd__decap_12
XFILLER_0_0_225 VPWR VGND VPWR VGND sky130_ef_sc_hd__decap_12
XFILLER_0_21_364 VGND VGND VPWR VPWR sky130_fd_sc_hd__fill_1
XTAP_504 VGND VPWR sky130_fd_sc_hd__tapvpwrvgnd_1
XTAP_515 VGND VPWR sky130_fd_sc_hd__tapvpwrvgnd_1
X_3260_ _1887_ _1864_ _1888_ VGND VGND VPWR VPWR _1889_ sky130_fd_sc_hd__a21oi_1
XTAP_526 VGND VPWR sky130_fd_sc_hd__tapvpwrvgnd_1
XTAP_537 VGND VPWR sky130_fd_sc_hd__tapvpwrvgnd_1
XTAP_548 VGND VPWR sky130_fd_sc_hd__tapvpwrvgnd_1
X_3191_ fifo3.mem\[0\]\[1\] fifo3.mem\[1\]\[1\] fifo3.mem\[2\]\[1\] fifo3.mem\[3\]\[1\]
+ _1805_ _1807_ VGND VGND VPWR VPWR _1822_ sky130_fd_sc_hd__mux4_1
XTAP_559 VGND VPWR sky130_fd_sc_hd__tapvpwrvgnd_1
X_2211_ _0762_ _1121_ _1125_ _1131_ VGND VGND VPWR VPWR _0225_ sky130_fd_sc_hd__a31o_1
X_2142_ _0762_ _1096_ _1097_ fifo1.mem\[9\]\[4\] VGND VGND VPWR VPWR _0189_ sky130_fd_sc_hd__a22o_1
XFILLER_0_76_526 VGND VGND VPWR VPWR sky130_fd_sc_hd__decap_6
XFILLER_0_91_529 VGND VGND VPWR VPWR sky130_fd_sc_hd__decap_3
XFILLER_0_29_486 VPWR VGND VPWR VGND sky130_ef_sc_hd__decap_12
X_4714_ clknet_leaf_1_clock _0520_ VGND VGND VPWR VPWR net37 sky130_fd_sc_hd__dfxtp_1
X_2975_ _1544_ _1677_ VGND VGND VPWR VPWR _1678_ sky130_fd_sc_hd__nand2_1
XFILLER_0_71_220 VGND VGND VPWR VPWR sky130_fd_sc_hd__decap_4
XFILLER_0_4_531 VGND VGND VPWR VPWR sky130_fd_sc_hd__fill_1
XFILLER_0_21_70 VGND VGND VPWR VPWR sky130_fd_sc_hd__decap_8
XFILLER_0_44_489 VGND VGND VPWR VPWR sky130_fd_sc_hd__decap_6
X_4645_ clknet_leaf_21_clock _0451_ VGND VGND VPWR VPWR fifo2.mem\[6\]\[4\] sky130_fd_sc_hd__dfxtp_1
XFILLER_0_12_331 VGND VGND VPWR VPWR sky130_fd_sc_hd__decap_6
X_4576_ clknet_leaf_56_clock _0382_ VGND VGND VPWR VPWR fifo3.mem\[15\]\[5\] sky130_fd_sc_hd__dfxtp_1
X_3527_ _1772_ _1420_ _1774_ _0790_ fifo3.mem\[11\]\[0\] VGND VGND VPWR VPWR _2095_
+ sky130_fd_sc_hd__o311ai_1
X_3458_ _1947_ _1953_ _1964_ VGND VGND VPWR VPWR _2059_ sky130_fd_sc_hd__o21a_1
X_3389_ _1547_ _1999_ _2001_ VGND VGND VPWR VPWR _2002_ sky130_fd_sc_hd__a21o_1
X_2409_ fifo1.mem\[5\]\[5\] VGND VGND VPWR VPWR _1294_ sky130_fd_sc_hd__inv_2
XFILLER_0_54_209 VGND VGND VPWR VPWR sky130_fd_sc_hd__decap_3
XFILLER_0_47_294 VGND VGND VPWR VPWR sky130_fd_sc_hd__decap_6
XFILLER_0_62_253 VGND VGND VPWR VPWR sky130_fd_sc_hd__fill_1
XFILLER_0_22_128 VGND VGND VPWR VPWR sky130_fd_sc_hd__fill_1
XFILLER_0_22_139 VGND VGND VPWR VPWR sky130_fd_sc_hd__fill_1
XFILLER_0_26_15 VPWR VGND VPWR VGND sky130_ef_sc_hd__decap_12
Xhold60 fifo1.mem\[3\]\[1\] VGND VGND VPWR VPWR net108 sky130_fd_sc_hd__dlygate4sd3_1
Xhold82 fifo3.mem\[3\]\[7\] VGND VGND VPWR VPWR net130 sky130_fd_sc_hd__dlygate4sd3_1
Xhold71 fifo2.mem\[11\]\[8\] VGND VGND VPWR VPWR net119 sky130_fd_sc_hd__dlygate4sd3_1
Xhold93 fifo1.mem\[0\]\[8\] VGND VGND VPWR VPWR net141 sky130_fd_sc_hd__dlygate4sd3_1
XFILLER_0_58_526 VGND VGND VPWR VPWR sky130_fd_sc_hd__decap_6
X_2760_ _0748_ _0751_ _0753_ _1099_ VGND VGND VPWR VPWR _1493_ sky130_fd_sc_hd__and4b_1
X_2691_ _1467_ _1438_ _0722_ fifo2.mem\[2\]\[5\] _0967_ VGND VGND VPWR VPWR _1473_
+ sky130_fd_sc_hd__o311a_1
X_4430_ clknet_leaf_49_clock _0012_ VGND VGND VPWR VPWR fsm1.full_state sky130_fd_sc_hd__dfxtp_1
XANTENNA_2 _0520_ VGND VGND VPWR VPWR sky130_fd_sc_hd__diode_2
X_4361_ clknet_leaf_45_clock _0175_ VGND VGND VPWR VPWR net39 sky130_fd_sc_hd__dfxtp_1
X_4292_ clknet_leaf_62_clock _0106_ VGND VGND VPWR VPWR fifo3.mem\[5\]\[1\] sky130_fd_sc_hd__dfxtp_1
XTAP_323 VGND VPWR sky130_fd_sc_hd__tapvpwrvgnd_1
XTAP_312 VGND VPWR sky130_fd_sc_hd__tapvpwrvgnd_1
XTAP_301 VGND VPWR sky130_fd_sc_hd__tapvpwrvgnd_1
X_3312_ _1935_ _1936_ _1938_ VGND VGND VPWR VPWR _1939_ sky130_fd_sc_hd__o21ai_1
XTAP_367 VGND VPWR sky130_fd_sc_hd__tapvpwrvgnd_1
XTAP_356 VGND VPWR sky130_fd_sc_hd__tapvpwrvgnd_1
XTAP_345 VGND VPWR sky130_fd_sc_hd__tapvpwrvgnd_1
XTAP_334 VGND VPWR sky130_fd_sc_hd__tapvpwrvgnd_1
X_3243_ _1846_ fifo3.mem\[0\]\[3\] _1835_ VGND VGND VPWR VPWR _1872_ sky130_fd_sc_hd__o21bai_1
XFILLER_0_67_99 VGND VGND VPWR VPWR sky130_fd_sc_hd__decap_4
XTAP_378 VGND VPWR sky130_fd_sc_hd__tapvpwrvgnd_1
XTAP_389 VGND VPWR sky130_fd_sc_hd__tapvpwrvgnd_1
X_3174_ _0009_ VGND VGND VPWR VPWR _1806_ sky130_fd_sc_hd__buf_4
X_2125_ net336 _1091_ _1093_ _0926_ VGND VGND VPWR VPWR _0177_ sky130_fd_sc_hd__a22o_1
XPHY_29 VGND VGND VPWR VPWR sky130_fd_sc_hd__decap_3
XPHY_18 VGND VGND VPWR VPWR sky130_fd_sc_hd__decap_3
XFILLER_0_91_337 VPWR VGND VPWR VGND sky130_ef_sc_hd__decap_12
XFILLER_0_17_423 VPWR VGND VPWR VGND sky130_ef_sc_hd__decap_12
XFILLER_0_29_272 VGND VGND VPWR VPWR sky130_fd_sc_hd__decap_8
XFILLER_0_64_529 VGND VGND VPWR VPWR sky130_fd_sc_hd__decap_3
X_2958_ fifo2.count\[2\] _1619_ _1554_ _0981_ _1661_ VGND VGND VPWR VPWR _0442_ sky130_fd_sc_hd__o311a_1
X_4628_ clknet_leaf_30_clock _0434_ VGND VGND VPWR VPWR net17 sky130_fd_sc_hd__dfxtp_1
XFILLER_0_4_361 VGND VGND VPWR VPWR sky130_fd_sc_hd__decap_3
X_2889_ _1550_ fifo2.mem\[6\]\[3\] _1562_ VGND VGND VPWR VPWR _1594_ sky130_fd_sc_hd__o21ai_1
X_4559_ clknet_leaf_27_clock _0365_ VGND VGND VPWR VPWR fifo2.mem\[2\]\[6\] sky130_fd_sc_hd__dfxtp_1
XTAP_890 VGND VPWR sky130_fd_sc_hd__tapvpwrvgnd_1
XFILLER_0_50_267 VGND VGND VPWR VPWR sky130_fd_sc_hd__fill_1
XFILLER_0_77_109 VGND VGND VPWR VPWR sky130_fd_sc_hd__decap_3
X_3930_ _0882_ _0888_ _0889_ VGND VGND VPWR VPWR _0890_ sky130_fd_sc_hd__and3b_1
XFILLER_0_53_57 VGND VGND VPWR VPWR sky130_fd_sc_hd__fill_2
XFILLER_0_58_356 VGND VGND VPWR VPWR sky130_fd_sc_hd__fill_1
X_3861_ _0781_ VGND VGND VPWR VPWR _0844_ sky130_fd_sc_hd__buf_2
XFILLER_0_85_197 VGND VGND VPWR VPWR sky130_fd_sc_hd__fill_1
X_3792_ _0785_ _0786_ fifo3.mem\[7\]\[3\] VGND VGND VPWR VPWR _0792_ sky130_fd_sc_hd__and3_1
X_2812_ fifo1.mem\[4\]\[1\] fifo1.mem\[5\]\[1\] fifo1.mem\[6\]\[1\] fifo1.mem\[7\]\[1\]
+ _1317_ _1339_ VGND VGND VPWR VPWR _1525_ sky130_fd_sc_hd__mux4_1
XFILLER_0_26_253 VGND VGND VPWR VPWR sky130_fd_sc_hd__decap_3
X_2743_ _1106_ _1488_ _1489_ net199 VGND VGND VPWR VPWR _0399_ sky130_fd_sc_hd__a22o_1
XFILLER_0_5_169 VGND VGND VPWR VPWR sky130_fd_sc_hd__decap_8
XFILLER_0_5_147 VGND VGND VPWR VPWR sky130_fd_sc_hd__fill_1
X_2674_ _1105_ _1465_ _1466_ net234 VGND VGND VPWR VPWR _0353_ sky130_fd_sc_hd__a22o_1
XFILLER_0_78_65 VGND VGND VPWR VPWR sky130_fd_sc_hd__decap_3
X_4413_ clknet_leaf_6_clock _0227_ VGND VGND VPWR VPWR fifo1.mem\[7\]\[6\] sky130_fd_sc_hd__dfxtp_1
X_4344_ clknet_leaf_49_clock _0158_ VGND VGND VPWR VPWR fsm1.parity_done sky130_fd_sc_hd__dfxtp_1
X_4275_ clknet_leaf_28_clock _0089_ VGND VGND VPWR VPWR fifo2.soft_reset sky130_fd_sc_hd__dfxtp_2
XTAP_186 VGND VPWR sky130_fd_sc_hd__tapvpwrvgnd_1
XTAP_197 VGND VPWR sky130_fd_sc_hd__tapvpwrvgnd_1
X_3226_ fifo3.mem\[7\]\[2\] VGND VGND VPWR VPWR _1856_ sky130_fd_sc_hd__inv_2
X_3157_ _0744_ _1152_ _1153_ net216 VGND VGND VPWR VPWR _0503_ sky130_fd_sc_hd__a22o_1
X_2108_ regis.packet_parity\[6\] regis.internal_parity\[6\] VGND VGND VPWR VPWR _1079_
+ sky130_fd_sc_hd__or2b_1
XFILLER_0_68_109 VGND VGND VPWR VPWR sky130_fd_sc_hd__fill_2
X_3088_ _1759_ _1419_ _0835_ _0782_ fifo3.mem\[2\]\[4\] VGND VGND VPWR VPWR _1765_
+ sky130_fd_sc_hd__o311a_1
XFILLER_0_49_334 VGND VGND VPWR VPWR sky130_fd_sc_hd__fill_2
XFILLER_0_76_175 VPWR VGND VPWR VGND sky130_ef_sc_hd__decap_12
XFILLER_0_76_197 VGND VGND VPWR VPWR sky130_fd_sc_hd__fill_2
XFILLER_0_9_486 VGND VGND VPWR VPWR sky130_fd_sc_hd__fill_2
Xclkbuf_leaf_53_clock clknet_3_1__leaf_clock VGND VGND VPWR VPWR clknet_leaf_53_clock
+ sky130_fd_sc_hd__clkbuf_16
XFILLER_0_13_492 VPWR VGND VPWR VGND sky130_ef_sc_hd__decap_12
XFILLER_0_87_418 VGND VGND VPWR VPWR sky130_fd_sc_hd__fill_1
XFILLER_0_23_27 VPWR VGND VPWR VGND sky130_ef_sc_hd__decap_12
XFILLER_0_67_120 VPWR VGND VPWR VGND sky130_ef_sc_hd__decap_12
XFILLER_0_23_234 VGND VGND VPWR VPWR sky130_fd_sc_hd__decap_4
XFILLER_0_23_256 VGND VGND VPWR VPWR sky130_fd_sc_hd__fill_1
X_2390_ _1189_ fifo1.mem\[12\]\[4\] _1182_ VGND VGND VPWR VPWR _1276_ sky130_fd_sc_hd__o21bai_1
XFILLER_0_3_15 VPWR VGND VPWR VGND sky130_ef_sc_hd__decap_12
X_4060_ _0853_ net47 _0972_ _0974_ VGND VGND VPWR VPWR _0975_ sky130_fd_sc_hd__a31oi_4
X_3011_ _1699_ _1712_ _1588_ _1616_ VGND VGND VPWR VPWR _1713_ sky130_fd_sc_hd__nand4_1
X_3913_ net40 _0693_ _0696_ VGND VGND VPWR VPWR _0878_ sky130_fd_sc_hd__and3_1
X_3844_ fifo3.wr_pointer\[3\] _0826_ _0769_ _0828_ VGND VGND VPWR VPWR _0829_ sky130_fd_sc_hd__nor4_1
X_3775_ _0777_ VGND VGND VPWR VPWR _0778_ sky130_fd_sc_hd__buf_2
XFILLER_0_54_381 VGND VGND VPWR VPWR sky130_fd_sc_hd__decap_4
X_2726_ _1094_ _1143_ _1102_ VGND VGND VPWR VPWR _1486_ sky130_fd_sc_hd__a21oi_4
X_2657_ _1461_ VGND VGND VPWR VPWR _1462_ sky130_fd_sc_hd__clkbuf_4
XFILLER_0_66_3 VPWR VGND VPWR VGND sky130_ef_sc_hd__decap_12
X_2588_ _0736_ _0869_ _1428_ _1434_ net105 VGND VGND VPWR VPWR _0299_ sky130_fd_sc_hd__a32o_1
XFILLER_0_10_473 VGND VGND VPWR VPWR sky130_fd_sc_hd__decap_3
X_4327_ clknet_leaf_39_clock _0141_ VGND VGND VPWR VPWR fifo1.temp sky130_fd_sc_hd__dfxtp_1
X_4258_ clknet_leaf_41_clock _0072_ VGND VGND VPWR VPWR fifo2.mem\[8\]\[1\] sky130_fd_sc_hd__dfxtp_1
X_3209_ _1830_ fifo3.mem\[14\]\[2\] _1835_ VGND VGND VPWR VPWR _1839_ sky130_fd_sc_hd__o21a_1
X_4189_ regis.packet_parity\[4\] _0682_ VGND VGND VPWR VPWR _1065_ sky130_fd_sc_hd__or2_1
XFILLER_0_37_337 VGND VGND VPWR VPWR sky130_fd_sc_hd__fill_2
XFILLER_0_60_362 VGND VGND VPWR VPWR sky130_fd_sc_hd__fill_2
XFILLER_0_20_259 VGND VGND VPWR VPWR sky130_fd_sc_hd__decap_8
Xhold190 fifo1.mem\[5\]\[0\] VGND VGND VPWR VPWR net238 sky130_fd_sc_hd__dlygate4sd3_1
XFILLER_0_18_27 VGND VGND VPWR VPWR sky130_fd_sc_hd__fill_1
XFILLER_0_87_237 VPWR VGND VPWR VGND sky130_ef_sc_hd__decap_12
XFILLER_0_87_204 VPWR VGND VPWR VGND sky130_ef_sc_hd__decap_12
XFILLER_0_83_443 VGND VGND VPWR VPWR sky130_fd_sc_hd__decap_4
XFILLER_0_50_25 VGND VGND VPWR VPWR sky130_fd_sc_hd__decap_3
XFILLER_0_50_69 VGND VGND VPWR VPWR sky130_fd_sc_hd__fill_1
X_3560_ _0735_ _1753_ _0920_ _2106_ net292 VGND VGND VPWR VPWR _0599_ sky130_fd_sc_hd__a32o_1
X_2511_ _1390_ _1392_ _1393_ VGND VGND VPWR VPWR _0263_ sky130_fd_sc_hd__a21oi_1
X_3491_ _2072_ _0783_ net258 _2079_ VGND VGND VPWR VPWR _0557_ sky130_fd_sc_hd__a31o_1
X_2442_ _1199_ _1202_ _1325_ _1326_ VGND VGND VPWR VPWR _1327_ sky130_fd_sc_hd__o211ai_1
X_2373_ _0617_ net10 VGND VGND VPWR VPWR _1259_ sky130_fd_sc_hd__and2_1
X_4112_ regis.header_byte\[4\] _0684_ _1012_ _0988_ VGND VGND VPWR VPWR _1013_ sky130_fd_sc_hd__o2bb2a_1
X_4043_ _0760_ _0960_ _0956_ _0964_ VGND VGND VPWR VPWR _0125_ sky130_fd_sc_hd__a31o_1
XFILLER_0_78_204 VGND VGND VPWR VPWR sky130_fd_sc_hd__fill_2
XFILLER_0_74_421 VPWR VGND VPWR VGND sky130_ef_sc_hd__decap_12
XFILLER_0_19_337 VGND VGND VPWR VPWR sky130_fd_sc_hd__fill_1
XFILLER_0_34_307 VGND VGND VPWR VPWR sky130_fd_sc_hd__fill_1
X_3827_ _0815_ _0739_ _0805_ VGND VGND VPWR VPWR _0816_ sky130_fd_sc_hd__mux2_1
XFILLER_0_46_178 VGND VGND VPWR VPWR sky130_fd_sc_hd__decap_8
X_3758_ _0742_ VGND VGND VPWR VPWR _0764_ sky130_fd_sc_hd__clkbuf_8
XFILLER_0_61_137 VGND VGND VPWR VPWR sky130_fd_sc_hd__fill_1
XFILLER_0_42_373 VGND VGND VPWR VPWR sky130_fd_sc_hd__decap_3
X_2709_ net300 _1478_ _1480_ _0936_ VGND VGND VPWR VPWR _0374_ sky130_fd_sc_hd__a22o_1
X_3689_ _0705_ syn.count0\[5\] syn.count0\[4\] VGND VGND VPWR VPWR _0711_ sky130_fd_sc_hd__or3b_1
XFILLER_0_69_237 VGND VGND VPWR VPWR sky130_fd_sc_hd__decap_4
XFILLER_0_77_281 VGND VGND VPWR VPWR sky130_fd_sc_hd__decap_4
Xclkbuf_3_6__f_clock clknet_0_clock VGND VGND VPWR VPWR clknet_3_6__leaf_clock sky130_fd_sc_hd__clkbuf_16
XFILLER_0_29_15 VPWR VGND VPWR VGND sky130_ef_sc_hd__decap_12
XTAP_708 VGND VPWR sky130_fd_sc_hd__tapvpwrvgnd_1
XTAP_719 VGND VPWR sky130_fd_sc_hd__tapvpwrvgnd_1
XFILLER_0_88_513 VPWR VGND VPWR VGND sky130_ef_sc_hd__decap_12
XFILLER_0_75_218 VGND VGND VPWR VPWR sky130_fd_sc_hd__decap_6
XFILLER_0_0_27 VGND VGND VPWR VPWR sky130_fd_sc_hd__fill_1
XFILLER_0_28_112 VPWR VGND VPWR VGND sky130_ef_sc_hd__decap_12
XFILLER_0_61_57 VGND VGND VPWR VPWR sky130_fd_sc_hd__fill_1
X_2991_ _1588_ _1616_ _1655_ _1692_ VGND VGND VPWR VPWR _1694_ sky130_fd_sc_hd__a31o_1
XFILLER_0_83_240 VPWR VGND VPWR VGND sky130_ef_sc_hd__decap_12
XFILLER_0_16_307 VGND VGND VPWR VPWR sky130_fd_sc_hd__fill_1
XFILLER_0_8_529 VGND VGND VPWR VPWR sky130_fd_sc_hd__decap_3
X_4730_ clknet_leaf_62_clock _0536_ VGND VGND VPWR VPWR net27 sky130_fd_sc_hd__dfxtp_1
XFILLER_0_61_68 VGND VGND VPWR VPWR sky130_fd_sc_hd__decap_3
XFILLER_0_71_435 VGND VGND VPWR VPWR sky130_fd_sc_hd__fill_1
X_4661_ clknet_leaf_2_clock _0467_ VGND VGND VPWR VPWR fifo3.mem\[2\]\[2\] sky130_fd_sc_hd__dfxtp_1
XFILLER_0_71_457 VGND VGND VPWR VPWR sky130_fd_sc_hd__fill_2
XFILLER_0_71_446 VGND VGND VPWR VPWR sky130_fd_sc_hd__fill_2
XFILLER_0_9_69 VPWR VGND VPWR VGND sky130_ef_sc_hd__decap_12
X_3612_ net2 _0649_ net1 VGND VGND VPWR VPWR _0650_ sky130_fd_sc_hd__or3b_1
X_4592_ clknet_leaf_10_clock _0398_ VGND VGND VPWR VPWR fifo1.mem\[10\]\[3\] sky130_fd_sc_hd__dfxtp_1
X_3543_ fifo3.wr_pointer\[2\] _0802_ VGND VGND VPWR VPWR _2102_ sky130_fd_sc_hd__and2_1
X_3474_ _2069_ VGND VGND VPWR VPWR _0550_ sky130_fd_sc_hd__clkbuf_1
X_2425_ _1189_ fifo1.mem\[12\]\[5\] _1233_ VGND VGND VPWR VPWR _1310_ sky130_fd_sc_hd__o21ba_1
X_2356_ fifo1.mem\[3\]\[3\] _1203_ _1242_ VGND VGND VPWR VPWR _1243_ sky130_fd_sc_hd__o21ai_1
X_2287_ _0002_ VGND VGND VPWR VPWR _1175_ sky130_fd_sc_hd__inv_2
X_4026_ fifo3.mem\[6\]\[7\] _0944_ _0942_ VGND VGND VPWR VPWR _0952_ sky130_fd_sc_hd__a21bo_1
XFILLER_0_29_3 VPWR VGND VPWR VGND sky130_ef_sc_hd__decap_12
XFILLER_0_59_281 VGND VGND VPWR VPWR sky130_fd_sc_hd__fill_1
XFILLER_0_66_229 VPWR VGND VPWR VGND sky130_ef_sc_hd__decap_12
XFILLER_0_74_251 VGND VGND VPWR VPWR sky130_fd_sc_hd__fill_1
XFILLER_0_74_240 VGND VGND VPWR VPWR sky130_fd_sc_hd__fill_1
XFILLER_0_74_273 VPWR VGND VPWR VGND sky130_ef_sc_hd__decap_12
XFILLER_0_62_435 VGND VGND VPWR VPWR sky130_fd_sc_hd__fill_1
XFILLER_0_15_351 VGND VGND VPWR VPWR sky130_fd_sc_hd__decap_3
XFILLER_0_30_321 VPWR VGND VPWR VGND sky130_ef_sc_hd__decap_12
XFILLER_0_85_505 VPWR VGND VPWR VGND sky130_ef_sc_hd__decap_12
XFILLER_0_65_240 VGND VGND VPWR VPWR sky130_fd_sc_hd__fill_2
XFILLER_0_25_137 VGND VGND VPWR VPWR sky130_fd_sc_hd__fill_1
XFILLER_0_25_148 VGND VGND VPWR VPWR sky130_fd_sc_hd__fill_1
XFILLER_0_0_237 VGND VGND VPWR VPWR sky130_fd_sc_hd__decap_8
XFILLER_0_0_215 VGND VGND VPWR VPWR sky130_fd_sc_hd__decap_8
XFILLER_0_21_332 VGND VGND VPWR VPWR sky130_fd_sc_hd__decap_4
XFILLER_0_33_192 VGND VGND VPWR VPWR sky130_fd_sc_hd__decap_8
XTAP_505 VGND VPWR sky130_fd_sc_hd__tapvpwrvgnd_1
XTAP_516 VGND VPWR sky130_fd_sc_hd__tapvpwrvgnd_1
XTAP_527 VGND VPWR sky130_fd_sc_hd__tapvpwrvgnd_1
XTAP_538 VGND VPWR sky130_fd_sc_hd__tapvpwrvgnd_1
XTAP_549 VGND VPWR sky130_fd_sc_hd__tapvpwrvgnd_1
X_2210_ _1126_ _1120_ fifo1.mem\[7\]\[4\] VGND VGND VPWR VPWR _1131_ sky130_fd_sc_hd__and3_1
X_3190_ _1820_ _1809_ VGND VGND VPWR VPWR _1821_ sky130_fd_sc_hd__and2_1
X_2141_ _0761_ _1096_ _1097_ net305 VGND VGND VPWR VPWR _0188_ sky130_fd_sc_hd__a22o_1
XFILLER_0_56_57 VGND VGND VPWR VPWR sky130_fd_sc_hd__fill_1
XFILLER_0_88_321 VPWR VGND VPWR VGND sky130_ef_sc_hd__decap_12
XFILLER_0_15_9 VPWR VGND VPWR VGND sky130_ef_sc_hd__decap_12
XFILLER_0_88_365 VPWR VGND VPWR VGND sky130_ef_sc_hd__decap_12
XFILLER_0_72_45 VGND VGND VPWR VPWR sky130_fd_sc_hd__fill_1
XFILLER_0_29_443 VGND VGND VPWR VPWR sky130_fd_sc_hd__decap_4
X_2974_ _1673_ _1674_ _1675_ _1676_ VGND VGND VPWR VPWR _1677_ sky130_fd_sc_hd__o22ai_1
XFILLER_0_16_115 VGND VGND VPWR VPWR sky130_fd_sc_hd__fill_2
X_4713_ clknet_leaf_56_clock _0519_ VGND VGND VPWR VPWR net36 sky130_fd_sc_hd__dfxtp_1
XFILLER_0_29_498 VGND VGND VPWR VPWR sky130_fd_sc_hd__decap_6
XFILLER_0_71_243 VGND VGND VPWR VPWR sky130_fd_sc_hd__fill_1
XFILLER_0_16_137 VGND VGND VPWR VPWR sky130_fd_sc_hd__decap_3
X_4644_ clknet_leaf_21_clock _0450_ VGND VGND VPWR VPWR fifo2.mem\[6\]\[3\] sky130_fd_sc_hd__dfxtp_1
X_4575_ clknet_leaf_55_clock _0381_ VGND VGND VPWR VPWR fifo3.mem\[15\]\[4\] sky130_fd_sc_hd__dfxtp_1
X_3526_ _2093_ VGND VGND VPWR VPWR _2094_ sky130_fd_sc_hd__clkbuf_4
XFILLER_0_12_365 VGND VGND VPWR VPWR sky130_fd_sc_hd__decap_8
X_3457_ _1904_ _1915_ _1941_ _2045_ VGND VGND VPWR VPWR _2058_ sky130_fd_sc_hd__and4_1
X_2408_ _1291_ _1292_ _1199_ _1202_ VGND VGND VPWR VPWR _1293_ sky130_fd_sc_hd__a211o_1
X_3388_ _2000_ _1623_ _1538_ VGND VGND VPWR VPWR _2001_ sky130_fd_sc_hd__a21o_1
X_2339_ _1198_ _1208_ _1213_ _1219_ _1226_ VGND VGND VPWR VPWR _1227_ sky130_fd_sc_hd__a32oi_4
XFILLER_0_79_321 VPWR VGND VPWR VGND sky130_ef_sc_hd__decap_12
X_4009_ _0769_ _0776_ _0781_ _0941_ VGND VGND VPWR VPWR _0942_ sky130_fd_sc_hd__nand4_4
XFILLER_0_47_251 VPWR VGND VPWR VGND sky130_ef_sc_hd__decap_12
XFILLER_0_30_195 VGND VGND VPWR VPWR sky130_fd_sc_hd__fill_1
Xhold50 fifo3.mem\[13\]\[0\] VGND VGND VPWR VPWR net98 sky130_fd_sc_hd__dlygate4sd3_1
Xhold61 fifo1.mem\[12\]\[1\] VGND VGND VPWR VPWR net109 sky130_fd_sc_hd__dlygate4sd3_1
Xhold72 fifo1.mem\[14\]\[1\] VGND VGND VPWR VPWR net120 sky130_fd_sc_hd__dlygate4sd3_1
XFILLER_0_26_27 VGND VGND VPWR VPWR sky130_fd_sc_hd__fill_1
Xhold83 fifo2.mem\[12\]\[5\] VGND VGND VPWR VPWR net131 sky130_fd_sc_hd__dlygate4sd3_1
Xhold94 fifo1.mem\[11\]\[3\] VGND VGND VPWR VPWR net142 sky130_fd_sc_hd__dlygate4sd3_1
XFILLER_0_85_335 VGND VGND VPWR VPWR sky130_fd_sc_hd__fill_1
XFILLER_0_41_405 VGND VGND VPWR VPWR sky130_fd_sc_hd__fill_1
X_2690_ _0762_ _0724_ _1436_ _1472_ VGND VGND VPWR VPWR _0363_ sky130_fd_sc_hd__a31o_1
XANTENNA_3 _0692_ VGND VGND VPWR VPWR sky130_fd_sc_hd__diode_2
X_4360_ clknet_leaf_44_clock _0174_ VGND VGND VPWR VPWR regis.packet_parity\[7\] sky130_fd_sc_hd__dfxtp_1
XFILLER_0_6_15 VPWR VGND VPWR VGND sky130_ef_sc_hd__decap_12
X_3311_ fifo3.mem\[15\]\[5\] _1838_ _1937_ VGND VGND VPWR VPWR _1938_ sky130_fd_sc_hd__o21ai_1
XFILLER_0_21_140 VGND VGND VPWR VPWR sky130_fd_sc_hd__fill_1
XTAP_324 VGND VPWR sky130_fd_sc_hd__tapvpwrvgnd_1
XTAP_313 VGND VPWR sky130_fd_sc_hd__tapvpwrvgnd_1
X_4291_ clknet_leaf_59_clock _0105_ VGND VGND VPWR VPWR fifo3.mem\[5\]\[0\] sky130_fd_sc_hd__dfxtp_1
XTAP_302 VGND VPWR sky130_fd_sc_hd__tapvpwrvgnd_1
XFILLER_0_67_45 VGND VGND VPWR VPWR sky130_fd_sc_hd__decap_8
XTAP_357 VGND VPWR sky130_fd_sc_hd__tapvpwrvgnd_1
XTAP_346 VGND VPWR sky130_fd_sc_hd__tapvpwrvgnd_1
XTAP_335 VGND VPWR sky130_fd_sc_hd__tapvpwrvgnd_1
X_3242_ fifo3.mem\[1\]\[3\] VGND VGND VPWR VPWR _1871_ sky130_fd_sc_hd__inv_2
X_3173_ _1804_ VGND VGND VPWR VPWR _1805_ sky130_fd_sc_hd__clkbuf_8
XTAP_368 VGND VPWR sky130_fd_sc_hd__tapvpwrvgnd_1
XTAP_379 VGND VPWR sky130_fd_sc_hd__tapvpwrvgnd_1
X_2124_ net290 _1091_ _1093_ _0925_ VGND VGND VPWR VPWR _0176_ sky130_fd_sc_hd__a22o_1
XFILLER_0_16_71 VGND VGND VPWR VPWR sky130_fd_sc_hd__fill_2
XPHY_19 VGND VGND VPWR VPWR sky130_fd_sc_hd__decap_3
XFILLER_0_49_505 VGND VGND VPWR VPWR sky130_fd_sc_hd__decap_4
XFILLER_0_49_538 VGND VGND VPWR VPWR sky130_fd_sc_hd__decap_3
XFILLER_0_91_305 VGND VGND VPWR VPWR sky130_fd_sc_hd__decap_3
XFILLER_0_91_349 VPWR VGND VPWR VGND sky130_ef_sc_hd__decap_12
X_2957_ _1554_ _1622_ _1660_ VGND VGND VPWR VPWR _1661_ sky130_fd_sc_hd__o21ai_1
XFILLER_0_17_435 VGND VGND VPWR VPWR sky130_fd_sc_hd__fill_1
XFILLER_0_32_81 VGND VGND VPWR VPWR sky130_fd_sc_hd__decap_3
XFILLER_0_44_221 VGND VGND VPWR VPWR sky130_fd_sc_hd__decap_6
X_2888_ _1591_ _1592_ _1554_ VGND VGND VPWR VPWR _1593_ sky130_fd_sc_hd__a21oi_1
XFILLER_0_44_243 VGND VGND VPWR VPWR sky130_fd_sc_hd__decap_3
XFILLER_0_32_427 VPWR VGND VPWR VGND sky130_ef_sc_hd__decap_12
X_4627_ clknet_leaf_1_clock _0433_ VGND VGND VPWR VPWR net16 sky130_fd_sc_hd__dfxtp_1
XFILLER_0_44_276 VGND VGND VPWR VPWR sky130_fd_sc_hd__fill_2
X_4558_ clknet_leaf_34_clock _0364_ VGND VGND VPWR VPWR fifo2.mem\[2\]\[5\] sky130_fd_sc_hd__dfxtp_1
X_3509_ _0925_ _2084_ _2085_ VGND VGND VPWR VPWR _0569_ sky130_fd_sc_hd__a21o_1
X_4489_ clknet_leaf_37_clock _0295_ VGND VGND VPWR VPWR fifo2.mem\[13\]\[8\] sky130_fd_sc_hd__dfxtp_1
XTAP_880 VGND VPWR sky130_fd_sc_hd__tapvpwrvgnd_1
XTAP_891 VGND VPWR sky130_fd_sc_hd__tapvpwrvgnd_1
XFILLER_0_12_29 VGND VGND VPWR VPWR sky130_fd_sc_hd__fill_1
XFILLER_0_23_405 VGND VGND VPWR VPWR sky130_fd_sc_hd__fill_2
XFILLER_0_23_449 VPWR VGND VPWR VGND sky130_ef_sc_hd__decap_12
Xoutput40 net40 VGND VGND VPWR VPWR valid_out_0 sky130_fd_sc_hd__clkbuf_4
XFILLER_0_37_15 VPWR VGND VPWR VGND sky130_ef_sc_hd__decap_12
XFILLER_0_53_36 VGND VGND VPWR VPWR sky130_fd_sc_hd__fill_2
XFILLER_0_85_165 VGND VGND VPWR VPWR sky130_fd_sc_hd__decap_3
X_3860_ _0759_ _0825_ _0838_ _0843_ VGND VGND VPWR VPWR _0063_ sky130_fd_sc_hd__a31o_1
X_2811_ _1519_ _1521_ _1198_ _1524_ _0875_ VGND VGND VPWR VPWR _0432_ sky130_fd_sc_hd__o221a_1
XFILLER_0_73_349 VGND VGND VPWR VPWR sky130_fd_sc_hd__fill_1
X_3791_ _0760_ _0778_ _0790_ _0791_ VGND VGND VPWR VPWR _0046_ sky130_fd_sc_hd__a31o_1
X_2742_ _1105_ _1488_ _1489_ net179 VGND VGND VPWR VPWR _0398_ sky130_fd_sc_hd__a22o_1
XFILLER_0_81_393 VPWR VGND VPWR VGND sky130_ef_sc_hd__decap_12
XFILLER_0_14_416 VGND VGND VPWR VPWR sky130_fd_sc_hd__decap_4
XFILLER_0_41_213 VGND VGND VPWR VPWR sky130_fd_sc_hd__decap_3
XFILLER_0_78_22 VGND VGND VPWR VPWR sky130_fd_sc_hd__decap_6
X_2673_ _1104_ _1465_ _1466_ net160 VGND VGND VPWR VPWR _0352_ sky130_fd_sc_hd__a22o_1
X_4412_ clknet_leaf_10_clock _0226_ VGND VGND VPWR VPWR fifo1.mem\[7\]\[5\] sky130_fd_sc_hd__dfxtp_1
XFILLER_0_1_321 VPWR VGND VPWR VGND sky130_ef_sc_hd__decap_12
XFILLER_0_41_279 VGND VGND VPWR VPWR sky130_fd_sc_hd__fill_1
X_4343_ clknet_leaf_45_clock _0157_ VGND VGND VPWR VPWR regis.header_byte\[7\] sky130_fd_sc_hd__dfxtp_1
XFILLER_0_22_493 VPWR VGND VPWR VGND sky130_ef_sc_hd__decap_12
X_4274_ clknet_leaf_28_clock _0088_ VGND VGND VPWR VPWR syn.count1\[5\] sky130_fd_sc_hd__dfxtp_1
X_3225_ _1853_ _1832_ _1854_ VGND VGND VPWR VPWR _1855_ sky130_fd_sc_hd__a21oi_1
XTAP_187 VGND VPWR sky130_fd_sc_hd__tapvpwrvgnd_1
XTAP_198 VGND VPWR sky130_fd_sc_hd__tapvpwrvgnd_1
X_3156_ _0743_ _1152_ _1153_ net235 VGND VGND VPWR VPWR _0502_ sky130_fd_sc_hd__a22o_1
X_2107_ regis.packet_parity\[1\] VGND VGND VPWR VPWR _1078_ sky130_fd_sc_hd__inv_2
X_3087_ _0761_ _0838_ _1758_ _1764_ VGND VGND VPWR VPWR _0468_ sky130_fd_sc_hd__a31o_1
XFILLER_0_11_3 VPWR VGND VPWR VGND sky130_ef_sc_hd__decap_12
XFILLER_0_9_421 VGND VGND VPWR VPWR sky130_fd_sc_hd__fill_2
XFILLER_0_91_113 VPWR VGND VPWR VGND sky130_ef_sc_hd__decap_12
XFILLER_0_76_187 VGND VGND VPWR VPWR sky130_fd_sc_hd__decap_8
X_3989_ _0928_ _0782_ fifo3.mem\[5\]\[2\] VGND VGND VPWR VPWR _0929_ sky130_fd_sc_hd__and3_1
XFILLER_0_67_132 VGND VGND VPWR VPWR sky130_fd_sc_hd__decap_8
XFILLER_0_23_39 VGND VGND VPWR VPWR sky130_fd_sc_hd__fill_1
XFILLER_0_36_530 VGND VGND VPWR VPWR sky130_fd_sc_hd__fill_2
XFILLER_0_67_187 VGND VGND VPWR VPWR sky130_fd_sc_hd__fill_1
XFILLER_0_63_393 VGND VGND VPWR VPWR sky130_fd_sc_hd__decap_3
XFILLER_0_48_25 VGND VGND VPWR VPWR sky130_fd_sc_hd__decap_3
XFILLER_0_3_27 VGND VGND VPWR VPWR sky130_fd_sc_hd__decap_8
XFILLER_0_3_38 VGND VGND VPWR VPWR sky130_fd_sc_hd__fill_2
XFILLER_0_64_35 VGND VGND VPWR VPWR sky130_fd_sc_hd__decap_8
X_3010_ _1701_ _1704_ _1711_ VGND VGND VPWR VPWR _1712_ sky130_fd_sc_hd__a21oi_1
XFILLER_0_58_132 VGND VGND VPWR VPWR sky130_fd_sc_hd__fill_1
XFILLER_0_80_45 VGND VGND VPWR VPWR sky130_fd_sc_hd__fill_2
X_3912_ _0658_ _0674_ _0875_ _0877_ VGND VGND VPWR VPWR _0081_ sky130_fd_sc_hd__o211a_1
XFILLER_0_80_67 VGND VGND VPWR VPWR sky130_fd_sc_hd__fill_1
X_3843_ _0773_ _0827_ _0775_ VGND VGND VPWR VPWR _0828_ sky130_fd_sc_hd__o21ai_1
XFILLER_0_73_146 VPWR VGND VPWR VGND sky130_ef_sc_hd__decap_12
XFILLER_0_14_213 VPWR VGND VPWR VGND sky130_ef_sc_hd__decap_12
X_3774_ _0770_ _0772_ _0776_ VGND VGND VPWR VPWR _0777_ sky130_fd_sc_hd__and3_1
XFILLER_0_42_533 VGND VGND VPWR VPWR sky130_fd_sc_hd__decap_8
X_2725_ _1484_ VGND VGND VPWR VPWR _1485_ sky130_fd_sc_hd__clkbuf_4
X_2656_ _0748_ _0751_ _0753_ _1150_ VGND VGND VPWR VPWR _1461_ sky130_fd_sc_hd__and4b_1
X_2587_ _0734_ _0869_ _1428_ _1434_ net295 VGND VGND VPWR VPWR _0298_ sky130_fd_sc_hd__a32o_1
XFILLER_0_59_3 VGND VGND VPWR VPWR sky130_fd_sc_hd__fill_1
X_4326_ clknet_leaf_27_clock _0140_ VGND VGND VPWR VPWR fifo2.mem\[0\]\[8\] sky130_fd_sc_hd__dfxtp_1
X_4257_ clknet_leaf_39_clock _0071_ VGND VGND VPWR VPWR fifo2.mem\[8\]\[0\] sky130_fd_sc_hd__dfxtp_1
X_3208_ _1834_ VGND VGND VPWR VPWR _1838_ sky130_fd_sc_hd__clkbuf_4
X_4188_ net4 _1059_ _1035_ _1064_ VGND VGND VPWR VPWR _0170_ sky130_fd_sc_hd__o211a_1
X_3139_ fifo3.mem\[4\]\[6\] _0842_ _1788_ VGND VGND VPWR VPWR _1796_ sky130_fd_sc_hd__a21bo_1
XFILLER_0_69_419 VGND VGND VPWR VPWR sky130_fd_sc_hd__decap_3
XFILLER_0_9_251 VGND VGND VPWR VPWR sky130_fd_sc_hd__fill_2
XFILLER_0_20_249 VGND VGND VPWR VPWR sky130_fd_sc_hd__decap_3
Xhold180 fifo1.mem\[11\]\[7\] VGND VGND VPWR VPWR net228 sky130_fd_sc_hd__dlygate4sd3_1
Xhold191 fifo3.mem\[14\]\[5\] VGND VGND VPWR VPWR net239 sky130_fd_sc_hd__dlygate4sd3_1
XFILLER_0_87_216 VGND VGND VPWR VPWR sky130_fd_sc_hd__decap_8
XFILLER_0_34_27 VGND VGND VPWR VPWR sky130_fd_sc_hd__fill_1
XFILLER_0_87_249 VPWR VGND VPWR VGND sky130_ef_sc_hd__decap_12
XFILLER_0_55_157 VGND VGND VPWR VPWR sky130_fd_sc_hd__fill_2
XFILLER_0_24_511 VPWR VGND VPWR VGND sky130_ef_sc_hd__decap_12
XFILLER_0_3_405 VPWR VGND VPWR VGND sky130_ef_sc_hd__decap_12
XFILLER_0_24_533 VGND VGND VPWR VPWR sky130_fd_sc_hd__decap_4
X_2510_ fifo1.count\[5\] _1259_ _1195_ _1120_ VGND VGND VPWR VPWR _1393_ sky130_fd_sc_hd__o31ai_1
XFILLER_0_3_449 VPWR VGND VPWR VGND sky130_ef_sc_hd__decap_12
X_3490_ _0742_ _2070_ _0829_ VGND VGND VPWR VPWR _2079_ sky130_fd_sc_hd__and3_1
X_2441_ _1227_ _1256_ _1282_ _1324_ VGND VGND VPWR VPWR _1326_ sky130_fd_sc_hd__a31o_1
XFILLER_0_59_57 VGND VGND VPWR VPWR sky130_fd_sc_hd__decap_4
X_2372_ _1231_ _1258_ _1121_ VGND VGND VPWR VPWR _0259_ sky130_fd_sc_hd__o21a_1
XFILLER_0_75_23 VGND VGND VPWR VPWR sky130_fd_sc_hd__fill_2
X_4111_ fifo1.lfd_state fifo1.data_in\[4\] VGND VGND VPWR VPWR _1012_ sky130_fd_sc_hd__or2b_1
X_4042_ _0957_ _0961_ _0962_ fifo2.mem\[1\]\[2\] _0963_ VGND VGND VPWR VPWR _0964_
+ sky130_fd_sc_hd__o311a_1
Xclkbuf_leaf_52_clock clknet_3_1__leaf_clock VGND VGND VPWR VPWR clknet_leaf_52_clock
+ sky130_fd_sc_hd__clkbuf_16
XFILLER_0_74_433 VGND VGND VPWR VPWR sky130_fd_sc_hd__decap_3
XFILLER_0_19_316 VGND VGND VPWR VPWR sky130_fd_sc_hd__decap_4
XFILLER_0_59_496 VGND VGND VPWR VPWR sky130_fd_sc_hd__decap_8
XFILLER_0_74_444 VGND VGND VPWR VPWR sky130_fd_sc_hd__fill_1
XFILLER_0_46_157 VPWR VGND VPWR VGND sky130_ef_sc_hd__decap_12
XFILLER_0_74_477 VPWR VGND VPWR VGND sky130_ef_sc_hd__decap_12
X_3826_ _0779_ fifo3.mem\[8\]\[5\] _0800_ VGND VGND VPWR VPWR _0815_ sky130_fd_sc_hd__and3_1
X_3757_ _0763_ _0755_ _0758_ net254 VGND VGND VPWR VPWR _0040_ sky130_fd_sc_hd__a22o_1
XFILLER_0_6_287 VGND VGND VPWR VPWR sky130_fd_sc_hd__fill_2
X_2708_ net338 _1478_ _1480_ _0934_ VGND VGND VPWR VPWR _0373_ sky130_fd_sc_hd__a22o_1
X_3688_ _0708_ syn.count0\[5\] VGND VGND VPWR VPWR _0710_ sky130_fd_sc_hd__nand2_1
X_2639_ _0747_ _0981_ _1446_ _1452_ VGND VGND VPWR VPWR _0332_ sky130_fd_sc_hd__a31o_1
X_4309_ clknet_leaf_28_clock _0123_ VGND VGND VPWR VPWR fifo2.mem\[1\]\[0\] sky130_fd_sc_hd__dfxtp_1
XFILLER_0_37_113 VGND VGND VPWR VPWR sky130_fd_sc_hd__decap_8
XFILLER_0_18_393 VGND VGND VPWR VPWR sky130_fd_sc_hd__fill_1
XFILLER_0_20_29 VGND VGND VPWR VPWR sky130_fd_sc_hd__fill_1
XFILLER_0_21_514 VPWR VGND VPWR VGND sky130_ef_sc_hd__decap_12
XFILLER_0_33_363 VGND VGND VPWR VPWR sky130_fd_sc_hd__fill_1
XFILLER_0_0_419 VGND VGND VPWR VPWR sky130_fd_sc_hd__fill_1
XFILLER_0_29_27 VGND VGND VPWR VPWR sky130_fd_sc_hd__decap_6
XTAP_709 VGND VPWR sky130_fd_sc_hd__tapvpwrvgnd_1
XFILLER_0_45_15 VPWR VGND VPWR VGND sky130_ef_sc_hd__decap_12
XFILLER_0_88_525 VGND VGND VPWR VPWR sky130_fd_sc_hd__decap_6
XFILLER_0_28_124 VPWR VGND VPWR VGND sky130_ef_sc_hd__decap_12
X_2990_ _1588_ _1616_ _1655_ _1692_ VGND VGND VPWR VPWR _1693_ sky130_fd_sc_hd__nand4_2
XFILLER_0_68_271 VGND VGND VPWR VPWR sky130_fd_sc_hd__decap_8
XFILLER_0_83_252 VGND VGND VPWR VPWR sky130_fd_sc_hd__decap_6
XFILLER_0_68_293 VGND VGND VPWR VPWR sky130_fd_sc_hd__fill_1
XFILLER_0_9_15 VPWR VGND VPWR VGND sky130_ef_sc_hd__decap_12
X_4660_ clknet_leaf_2_clock _0466_ VGND VGND VPWR VPWR fifo3.mem\[2\]\[1\] sky130_fd_sc_hd__dfxtp_1
XFILLER_0_43_105 VGND VGND VPWR VPWR sky130_fd_sc_hd__decap_6
XFILLER_0_56_477 VGND VGND VPWR VPWR sky130_fd_sc_hd__fill_2
X_3611_ fifo2.soft_reset fifo3.soft_reset VGND VGND VPWR VPWR _0649_ sky130_fd_sc_hd__nor2_1
X_4591_ clknet_leaf_9_clock _0397_ VGND VGND VPWR VPWR fifo1.mem\[10\]\[2\] sky130_fd_sc_hd__dfxtp_1
X_3542_ _0939_ _2094_ _2101_ VGND VGND VPWR VPWR _0586_ sky130_fd_sc_hd__a21bo_1
XFILLER_0_3_257 VGND VGND VPWR VPWR sky130_fd_sc_hd__decap_6
XFILLER_0_3_279 VGND VGND VPWR VPWR sky130_fd_sc_hd__fill_1
X_3473_ _1168_ _1169_ _1170_ VGND VGND VPWR VPWR _2069_ sky130_fd_sc_hd__and3b_1
X_2424_ _1305_ _1308_ _1175_ VGND VGND VPWR VPWR _1309_ sky130_fd_sc_hd__o21ai_2
X_2355_ _1221_ fifo1.mem\[2\]\[3\] _1182_ VGND VGND VPWR VPWR _1242_ sky130_fd_sc_hd__o21a_1
X_2286_ fifo1.count\[0\] _1173_ VGND VGND VPWR VPWR _1174_ sky130_fd_sc_hd__nor2_1
XFILLER_0_79_503 VGND VGND VPWR VPWR sky130_fd_sc_hd__fill_1
X_4025_ _0936_ _0943_ _0951_ VGND VGND VPWR VPWR _0120_ sky130_fd_sc_hd__o21a_1
XFILLER_0_66_219 VGND VGND VPWR VPWR sky130_fd_sc_hd__fill_2
XFILLER_0_59_271 VGND VGND VPWR VPWR sky130_fd_sc_hd__fill_2
XFILLER_0_74_230 VGND VGND VPWR VPWR sky130_fd_sc_hd__fill_2
XFILLER_0_74_285 VPWR VGND VPWR VGND sky130_ef_sc_hd__decap_12
X_3809_ _0633_ _0773_ _0774_ _0775_ fifo3.wr_pointer\[3\] VGND VGND VPWR VPWR _0803_
+ sky130_fd_sc_hd__o311a_4
X_4789_ clknet_leaf_48_clock _0595_ VGND VGND VPWR VPWR fifo3.mem\[12\]\[8\] sky130_fd_sc_hd__dfxtp_1
XFILLER_0_30_333 VPWR VGND VPWR VGND sky130_ef_sc_hd__decap_12
XFILLER_0_85_517 VPWR VGND VPWR VGND sky130_ef_sc_hd__decap_12
XFILLER_0_57_219 VGND VGND VPWR VPWR sky130_fd_sc_hd__decap_4
XFILLER_0_38_433 VGND VGND VPWR VPWR sky130_fd_sc_hd__fill_1
XFILLER_0_53_436 VPWR VGND VPWR VGND sky130_ef_sc_hd__decap_12
XTAP_506 VGND VPWR sky130_fd_sc_hd__tapvpwrvgnd_1
XTAP_517 VGND VPWR sky130_fd_sc_hd__tapvpwrvgnd_1
XTAP_528 VGND VPWR sky130_fd_sc_hd__tapvpwrvgnd_1
XTAP_539 VGND VPWR sky130_fd_sc_hd__tapvpwrvgnd_1
XFILLER_0_56_14 VGND VGND VPWR VPWR sky130_fd_sc_hd__fill_1
X_2140_ _0760_ _1096_ _1097_ net301 VGND VGND VPWR VPWR _0187_ sky130_fd_sc_hd__a22o_1
XFILLER_0_88_333 VPWR VGND VPWR VGND sky130_ef_sc_hd__decap_12
XFILLER_0_88_377 VPWR VGND VPWR VGND sky130_ef_sc_hd__decap_12
X_2973_ fifo2.mem\[1\]\[5\] _1539_ VGND VGND VPWR VPWR _1676_ sky130_fd_sc_hd__and2b_1
XFILLER_0_29_455 VGND VGND VPWR VPWR sky130_fd_sc_hd__fill_1
XFILLER_0_56_230 VGND VGND VPWR VPWR sky130_fd_sc_hd__decap_8
X_4712_ clknet_leaf_61_clock _0518_ VGND VGND VPWR VPWR net35 sky130_fd_sc_hd__dfxtp_1
XFILLER_0_16_149 VGND VGND VPWR VPWR sky130_fd_sc_hd__decap_3
XFILLER_0_4_533 VGND VGND VPWR VPWR sky130_fd_sc_hd__decap_8
X_4643_ clknet_leaf_22_clock _0449_ VGND VGND VPWR VPWR fifo2.mem\[6\]\[2\] sky130_fd_sc_hd__dfxtp_1
X_4574_ clknet_leaf_49_clock _0380_ VGND VGND VPWR VPWR fifo3.mem\[15\]\[3\] sky130_fd_sc_hd__dfxtp_1
X_3525_ _0770_ _0772_ _0781_ _0803_ VGND VGND VPWR VPWR _2093_ sky130_fd_sc_hd__and4b_1
X_3456_ _2053_ _2032_ _2046_ _2056_ VGND VGND VPWR VPWR _2057_ sky130_fd_sc_hd__o31ai_1
X_2407_ _1286_ _1173_ fifo1.count\[3\] VGND VGND VPWR VPWR _1292_ sky130_fd_sc_hd__o21ai_1
X_3387_ fifo2.mem\[12\]\[1\] fifo2.mem\[13\]\[1\] fifo2.mem\[14\]\[1\] fifo2.mem\[15\]\[1\]
+ _1669_ _1702_ VGND VGND VPWR VPWR _2000_ sky130_fd_sc_hd__mux4_2
XFILLER_0_41_3 VPWR VGND VPWR VGND sky130_ef_sc_hd__decap_12
X_2338_ _1223_ _1225_ _0002_ VGND VGND VPWR VPWR _1226_ sky130_fd_sc_hd__a21o_2
X_2269_ _1155_ _1160_ _1161_ VGND VGND VPWR VPWR _0253_ sky130_fd_sc_hd__a21oi_1
XFILLER_0_79_333 VGND VGND VPWR VPWR sky130_fd_sc_hd__decap_3
X_4008_ fifo3.wr_pointer\[0\] _0823_ VGND VGND VPWR VPWR _0941_ sky130_fd_sc_hd__and2b_1
XFILLER_0_47_263 VPWR VGND VPWR VGND sky130_ef_sc_hd__decap_12
XFILLER_0_90_531 VGND VGND VPWR VPWR sky130_fd_sc_hd__fill_1
XFILLER_0_35_447 VGND VGND VPWR VPWR sky130_fd_sc_hd__fill_1
Xhold40 fifo2.mem\[14\]\[8\] VGND VGND VPWR VPWR net88 sky130_fd_sc_hd__dlygate4sd3_1
Xhold51 fifo3.mem\[14\]\[2\] VGND VGND VPWR VPWR net99 sky130_fd_sc_hd__dlygate4sd3_1
Xhold73 fifo2.mem\[13\]\[1\] VGND VGND VPWR VPWR net121 sky130_fd_sc_hd__dlygate4sd3_1
Xhold62 fifo1.mem\[14\]\[2\] VGND VGND VPWR VPWR net110 sky130_fd_sc_hd__dlygate4sd3_1
Xhold95 fifo1.mem\[3\]\[6\] VGND VGND VPWR VPWR net143 sky130_fd_sc_hd__dlygate4sd3_1
Xhold84 fifo3.mem\[14\]\[1\] VGND VGND VPWR VPWR net132 sky130_fd_sc_hd__dlygate4sd3_1
XFILLER_0_42_27 VGND VGND VPWR VPWR sky130_fd_sc_hd__fill_1
XFILLER_0_5_319 VGND VGND VPWR VPWR sky130_fd_sc_hd__fill_1
XFILLER_0_1_503 VGND VGND VPWR VPWR sky130_fd_sc_hd__fill_1
XANTENNA_4 _0874_ VGND VGND VPWR VPWR sky130_fd_sc_hd__diode_2
X_3310_ _0008_ fifo3.mem\[14\]\[5\] _1841_ VGND VGND VPWR VPWR _1937_ sky130_fd_sc_hd__o21a_1
XFILLER_0_6_27 VGND VGND VPWR VPWR sky130_fd_sc_hd__fill_1
XTAP_314 VGND VPWR sky130_fd_sc_hd__tapvpwrvgnd_1
XTAP_303 VGND VPWR sky130_fd_sc_hd__tapvpwrvgnd_1
X_4290_ clknet_leaf_43_clock _0104_ VGND VGND VPWR VPWR regis.fifo_full_state\[7\]
+ sky130_fd_sc_hd__dfxtp_1
XFILLER_0_67_57 VGND VGND VPWR VPWR sky130_fd_sc_hd__decap_3
XTAP_358 VGND VPWR sky130_fd_sc_hd__tapvpwrvgnd_1
XTAP_347 VGND VPWR sky130_fd_sc_hd__tapvpwrvgnd_1
XTAP_336 VGND VPWR sky130_fd_sc_hd__tapvpwrvgnd_1
XTAP_325 VGND VPWR sky130_fd_sc_hd__tapvpwrvgnd_1
X_3241_ _1866_ _1869_ _1827_ VGND VGND VPWR VPWR _1870_ sky130_fd_sc_hd__o21ai_1
X_3172_ _0008_ VGND VGND VPWR VPWR _1804_ sky130_fd_sc_hd__clkbuf_4
XTAP_369 VGND VPWR sky130_fd_sc_hd__tapvpwrvgnd_1
X_2123_ _1092_ VGND VGND VPWR VPWR _1093_ sky130_fd_sc_hd__buf_2
XFILLER_0_88_141 VGND VGND VPWR VPWR sky130_fd_sc_hd__fill_1
XFILLER_0_76_303 VGND VGND VPWR VPWR sky130_fd_sc_hd__decap_4
XFILLER_0_16_83 VGND VGND VPWR VPWR sky130_fd_sc_hd__fill_1
XFILLER_0_64_509 VPWR VGND VPWR VGND sky130_ef_sc_hd__decap_12
XFILLER_0_72_531 VGND VGND VPWR VPWR sky130_fd_sc_hd__fill_1
XFILLER_0_17_447 VGND VGND VPWR VPWR sky130_fd_sc_hd__fill_1
X_2956_ _1554_ _1656_ _1659_ VGND VGND VPWR VPWR _1660_ sky130_fd_sc_hd__nand3_1
X_2887_ fifo2.count\[1\] fifo2.count\[0\] net11 net41 VGND VGND VPWR VPWR _1592_ sky130_fd_sc_hd__or4bb_1
XFILLER_0_89_3 VPWR VGND VPWR VGND sky130_ef_sc_hd__decap_12
X_4626_ clknet_leaf_26_clock _0432_ VGND VGND VPWR VPWR net15 sky130_fd_sc_hd__dfxtp_1
XFILLER_0_32_439 VGND VGND VPWR VPWR sky130_fd_sc_hd__decap_6
XFILLER_0_12_141 VGND VGND VPWR VPWR sky130_fd_sc_hd__decap_8
X_4557_ clknet_leaf_22_clock _0363_ VGND VGND VPWR VPWR fifo2.mem\[2\]\[4\] sky130_fd_sc_hd__dfxtp_1
X_3508_ _1760_ _1779_ _1781_ fifo3.mem\[10\]\[0\] _1783_ VGND VGND VPWR VPWR _2085_
+ sky130_fd_sc_hd__o311a_1
X_4488_ clknet_leaf_37_clock _0294_ VGND VGND VPWR VPWR fifo2.mem\[13\]\[7\] sky130_fd_sc_hd__dfxtp_1
X_3439_ fifo3.count\[3\] net42 _1399_ net12 VGND VGND VPWR VPWR _2042_ sky130_fd_sc_hd__and4b_1
XTAP_870 VGND VPWR sky130_fd_sc_hd__tapvpwrvgnd_1
XTAP_892 VGND VPWR sky130_fd_sc_hd__tapvpwrvgnd_1
XTAP_881 VGND VPWR sky130_fd_sc_hd__tapvpwrvgnd_1
XFILLER_0_79_141 VGND VGND VPWR VPWR sky130_fd_sc_hd__fill_1
XFILLER_0_79_185 VGND VGND VPWR VPWR sky130_fd_sc_hd__decap_4
XFILLER_0_67_314 VGND VGND VPWR VPWR sky130_fd_sc_hd__fill_1
XFILLER_0_67_358 VPWR VGND VPWR VGND sky130_ef_sc_hd__decap_12
XFILLER_0_35_222 VGND VGND VPWR VPWR sky130_fd_sc_hd__fill_2
XFILLER_0_35_244 VGND VGND VPWR VPWR sky130_fd_sc_hd__fill_1
Xoutput30 net30 VGND VGND VPWR VPWR data_out_1[7] sky130_fd_sc_hd__clkbuf_4
Xoutput41 net41 VGND VGND VPWR VPWR valid_out_1 sky130_fd_sc_hd__clkbuf_4
XFILLER_0_37_27 VPWR VGND VPWR VGND sky130_ef_sc_hd__decap_12
XFILLER_0_85_111 VGND VGND VPWR VPWR sky130_fd_sc_hd__fill_1
X_2810_ _1522_ _1523_ _1187_ VGND VGND VPWR VPWR _1524_ sky130_fd_sc_hd__mux2_1
X_3790_ _0785_ _0786_ fifo3.mem\[7\]\[2\] VGND VGND VPWR VPWR _0791_ sky130_fd_sc_hd__and3_1
XPHY_180 VGND VGND VPWR VPWR sky130_fd_sc_hd__decap_3
X_2741_ _1104_ _1488_ _1489_ net137 VGND VGND VPWR VPWR _0397_ sky130_fd_sc_hd__a22o_1
XFILLER_0_81_361 VPWR VGND VPWR VGND sky130_ef_sc_hd__decap_12
XFILLER_0_14_428 VGND VGND VPWR VPWR sky130_fd_sc_hd__decap_8
X_2672_ _1098_ _1465_ _1466_ net198 VGND VGND VPWR VPWR _0351_ sky130_fd_sc_hd__a22o_1
X_4411_ clknet_leaf_7_clock _0225_ VGND VGND VPWR VPWR fifo1.mem\[7\]\[4\] sky130_fd_sc_hd__dfxtp_1
XFILLER_0_1_333 VGND VGND VPWR VPWR sky130_fd_sc_hd__decap_3
X_4342_ clknet_leaf_45_clock _0156_ VGND VGND VPWR VPWR regis.header_byte\[6\] sky130_fd_sc_hd__dfxtp_1
X_4273_ clknet_leaf_29_clock _0087_ VGND VGND VPWR VPWR syn.count1\[4\] sky130_fd_sc_hd__dfxtp_1
X_3224_ _1804_ fifo3.mem\[4\]\[2\] _1841_ VGND VGND VPWR VPWR _1854_ sky130_fd_sc_hd__o21bai_1
.ends
